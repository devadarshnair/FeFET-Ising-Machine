* t1d/t1d_w05.cir -- generated by device/tb/make_fefet_mw.py (width 1e-05 s)
* Test 1d: set B FeFET (W = L = 1 um), memory window vs write pulse (T4 of Ni 2018).
* Instance k = amplitude index (2.0 2.5 3.0 3.5 4.0 4.5 V). Reads: ramp -1.2 ... 1.8 V,
* V_DS = 50 mV, 2 s after each write. Checker: device/tb/check_t1d.py.
.include ../../ngspice/fefet_preisach.lib
.options reltol=1e-4 abstol=1e-15 method=gear
Vg0 g0 0 pwl(
+ 0 0 0.01009099 0 0.010090995 2 0.010100995 2 0.010101 0 2.02019099 0
+ 2.020190995 -2 2.020200995 -2 2.020201 0 4.020201 0 4.020202 -1.2 4.02020217333 -1.18
+ 4.02020234667 -1.16 4.02020252 -1.14 4.02020269333 -1.12 4.02020286667 -1.1 4.02020304 -1.08 4.02020321333 -1.06
+ 4.02020338667 -1.04 4.02020356 -1.02 4.02020373333 -1 4.02020390667 -0.98 4.02020408 -0.96 4.02020425333 -0.94
+ 4.02020442667 -0.92 4.0202046 -0.9 4.02020477333 -0.88 4.02020494667 -0.86 4.02020512 -0.84 4.02020529333 -0.82
+ 4.02020546667 -0.8 4.02020564 -0.78 4.02020581333 -0.76 4.02020598667 -0.74 4.02020616 -0.72 4.02020633333 -0.7
+ 4.02020650667 -0.68 4.02020668 -0.66 4.02020685333 -0.64 4.02020702667 -0.62 4.0202072 -0.6 4.02020737333 -0.58
+ 4.02020754667 -0.56 4.02020772 -0.54 4.02020789333 -0.52 4.02020806667 -0.5 4.02020824 -0.48 4.02020841333 -0.46
+ 4.02020858667 -0.44 4.02020876 -0.42 4.02020893333 -0.4 4.02020910667 -0.38 4.02020928 -0.36 4.02020945333 -0.34
+ 4.02020962667 -0.32 4.0202098 -0.3 4.02020997333 -0.28 4.02021014667 -0.26 4.02021032 -0.24 4.02021049333 -0.22
+ 4.02021066667 -0.2 4.02021084 -0.18 4.02021101333 -0.16 4.02021118667 -0.14 4.02021136 -0.12 4.02021153333 -0.1
+ 4.02021170667 -0.08 4.02021188 -0.06 4.02021205333 -0.04 4.02021222667 -0.02 4.0202124 0 4.02021257333 0.02
+ 4.02021274667 0.04 4.02021292 0.06 4.02021309333 0.08 4.02021326667 0.1 4.02021344 0.12 4.02021361333 0.14
+ 4.02021378667 0.16 4.02021396 0.18 4.02021413333 0.2 4.02021430667 0.22 4.02021448 0.24 4.02021465333 0.26
+ 4.02021482667 0.28 4.020215 0.3 4.02021517333 0.32 4.02021534667 0.34 4.02021552 0.36 4.02021569333 0.38
+ 4.02021586667 0.4 4.02021604 0.42 4.02021621333 0.44 4.02021638667 0.46 4.02021656 0.48 4.02021673333 0.5
+ 4.02021690667 0.52 4.02021708 0.54 4.02021725333 0.56 4.02021742667 0.58 4.0202176 0.6 4.02021777333 0.62
+ 4.02021794667 0.64 4.02021812 0.66 4.02021829333 0.68 4.02021846667 0.7 4.02021864 0.72 4.02021881333 0.74
+ 4.02021898667 0.76 4.02021916 0.78 4.02021933333 0.8 4.02021950667 0.82 4.02021968 0.84 4.02021985333 0.86
+ 4.02022002667 0.88 4.0202202 0.9 4.02022037333 0.92 4.02022054667 0.94 4.02022072 0.96 4.02022089333 0.98
+ 4.02022106667 1 4.02022124 1.02 4.02022141333 1.04 4.02022158667 1.06 4.02022176 1.08 4.02022193333 1.1
+ 4.02022210667 1.12 4.02022228 1.14 4.02022245333 1.16 4.02022262667 1.18 4.0202228 1.2 4.02022297333 1.22
+ 4.02022314667 1.24 4.02022332 1.26 4.02022349333 1.28 4.02022366667 1.3 4.02022384 1.32 4.02022401333 1.34
+ 4.02022418667 1.36 4.02022436 1.38 4.02022453333 1.4 4.02022470667 1.42 4.02022488 1.44 4.02022505333 1.46
+ 4.02022522667 1.48 4.0202254 1.5 4.02022557333 1.52 4.02022574667 1.54 4.02022592 1.56 4.02022609333 1.58
+ 4.02022626667 1.6 4.02022644 1.62 4.02022661333 1.64 4.02022678667 1.66 4.02022696 1.68 4.02022713333 1.7
+ 4.02022730667 1.72 4.02022748 1.74 4.02022765333 1.76 4.02022782667 1.78 4.020228 1.8 4.020229 0
+ 4.03031899 0 4.030318995 2 4.030328995 2 4.030329 0 6.030329 0 6.03033 -1.2
+ 6.03033017333 -1.18 6.03033034667 -1.16 6.03033052 -1.14 6.03033069333 -1.12 6.03033086667 -1.1 6.03033104 -1.08
+ 6.03033121333 -1.06 6.03033138667 -1.04 6.03033156 -1.02 6.03033173333 -1 6.03033190667 -0.98 6.03033208 -0.96
+ 6.03033225333 -0.94 6.03033242667 -0.92 6.0303326 -0.9 6.03033277333 -0.88 6.03033294667 -0.86 6.03033312 -0.84
+ 6.03033329333 -0.82 6.03033346667 -0.8 6.03033364 -0.78 6.03033381333 -0.76 6.03033398667 -0.74 6.03033416 -0.72
+ 6.03033433333 -0.7 6.03033450667 -0.68 6.03033468 -0.66 6.03033485333 -0.64 6.03033502667 -0.62 6.0303352 -0.6
+ 6.03033537333 -0.58 6.03033554667 -0.56 6.03033572 -0.54 6.03033589333 -0.52 6.03033606667 -0.5 6.03033624 -0.48
+ 6.03033641333 -0.46 6.03033658667 -0.44 6.03033676 -0.42 6.03033693333 -0.4 6.03033710667 -0.38 6.03033728 -0.36
+ 6.03033745333 -0.34 6.03033762667 -0.32 6.0303378 -0.3 6.03033797333 -0.28 6.03033814667 -0.26 6.03033832 -0.24
+ 6.03033849333 -0.22 6.03033866667 -0.2 6.03033884 -0.18 6.03033901333 -0.16 6.03033918667 -0.14 6.03033936 -0.12
+ 6.03033953333 -0.1 6.03033970667 -0.08 6.03033988 -0.06 6.03034005333 -0.04 6.03034022667 -0.02 6.0303404 0
+ 6.03034057333 0.02 6.03034074667 0.04 6.03034092 0.06 6.03034109333 0.08 6.03034126667 0.1 6.03034144 0.12
+ 6.03034161333 0.14 6.03034178667 0.16 6.03034196 0.18 6.03034213333 0.2 6.03034230667 0.22 6.03034248 0.24
+ 6.03034265333 0.26 6.03034282667 0.28 6.030343 0.3 6.03034317333 0.32 6.03034334667 0.34 6.03034352 0.36
+ 6.03034369333 0.38 6.03034386667 0.4 6.03034404 0.42 6.03034421333 0.44 6.03034438667 0.46 6.03034456 0.48
+ 6.03034473333 0.5 6.03034490667 0.52 6.03034508 0.54 6.03034525333 0.56 6.03034542667 0.58 6.0303456 0.6
+ 6.03034577333 0.62 6.03034594667 0.64 6.03034612 0.66 6.03034629333 0.68 6.03034646667 0.7 6.03034664 0.72
+ 6.03034681333 0.74 6.03034698667 0.76 6.03034716 0.78 6.03034733333 0.8 6.03034750667 0.82 6.03034768 0.84
+ 6.03034785333 0.86 6.03034802667 0.88 6.0303482 0.9 6.03034837333 0.92 6.03034854667 0.94 6.03034872 0.96
+ 6.03034889333 0.98 6.03034906667 1 6.03034924 1.02 6.03034941333 1.04 6.03034958667 1.06 6.03034976 1.08
+ 6.03034993333 1.1 6.03035010667 1.12 6.03035028 1.14 6.03035045333 1.16 6.03035062667 1.18 6.0303508 1.2
+ 6.03035097333 1.22 6.03035114667 1.24 6.03035132 1.26 6.03035149333 1.28 6.03035166667 1.3 6.03035184 1.32
+ 6.03035201333 1.34 6.03035218667 1.36 6.03035236 1.38 6.03035253333 1.4 6.03035270667 1.42 6.03035288 1.44
+ 6.03035305333 1.46 6.03035322667 1.48 6.0303534 1.5 6.03035357333 1.52 6.03035374667 1.54 6.03035392 1.56
+ 6.03035409333 1.58 6.03035426667 1.6 6.03035444 1.62 6.03035461333 1.64 6.03035478667 1.66 6.03035496 1.68
+ 6.03035513333 1.7 6.03035530667 1.72 6.03035548 1.74 6.03035565333 1.76 6.03035582667 1.78 6.030356 1.8
+ 6.030357 0)
Vd0 d0 0 pwl(
+ 0 0 4.0202004 0 4.0202005 0.05 4.0202291 0.05 4.0202292 0 6.0303284 0
+ 6.0303285 0.05 6.0303571 0.05 6.0303572 0)
X0 g0 d0 0 0 fefet_b16
Vg1 g1 0 pwl(
+ 0 0 0.01009099 0 0.010090995 2.5 0.010100995 2.5 0.010101 0 2.02019099 0
+ 2.020190995 -2.5 2.020200995 -2.5 2.020201 0 4.020201 0 4.020202 -1.2 4.02020217333 -1.18
+ 4.02020234667 -1.16 4.02020252 -1.14 4.02020269333 -1.12 4.02020286667 -1.1 4.02020304 -1.08 4.02020321333 -1.06
+ 4.02020338667 -1.04 4.02020356 -1.02 4.02020373333 -1 4.02020390667 -0.98 4.02020408 -0.96 4.02020425333 -0.94
+ 4.02020442667 -0.92 4.0202046 -0.9 4.02020477333 -0.88 4.02020494667 -0.86 4.02020512 -0.84 4.02020529333 -0.82
+ 4.02020546667 -0.8 4.02020564 -0.78 4.02020581333 -0.76 4.02020598667 -0.74 4.02020616 -0.72 4.02020633333 -0.7
+ 4.02020650667 -0.68 4.02020668 -0.66 4.02020685333 -0.64 4.02020702667 -0.62 4.0202072 -0.6 4.02020737333 -0.58
+ 4.02020754667 -0.56 4.02020772 -0.54 4.02020789333 -0.52 4.02020806667 -0.5 4.02020824 -0.48 4.02020841333 -0.46
+ 4.02020858667 -0.44 4.02020876 -0.42 4.02020893333 -0.4 4.02020910667 -0.38 4.02020928 -0.36 4.02020945333 -0.34
+ 4.02020962667 -0.32 4.0202098 -0.3 4.02020997333 -0.28 4.02021014667 -0.26 4.02021032 -0.24 4.02021049333 -0.22
+ 4.02021066667 -0.2 4.02021084 -0.18 4.02021101333 -0.16 4.02021118667 -0.14 4.02021136 -0.12 4.02021153333 -0.1
+ 4.02021170667 -0.08 4.02021188 -0.06 4.02021205333 -0.04 4.02021222667 -0.02 4.0202124 0 4.02021257333 0.02
+ 4.02021274667 0.04 4.02021292 0.06 4.02021309333 0.08 4.02021326667 0.1 4.02021344 0.12 4.02021361333 0.14
+ 4.02021378667 0.16 4.02021396 0.18 4.02021413333 0.2 4.02021430667 0.22 4.02021448 0.24 4.02021465333 0.26
+ 4.02021482667 0.28 4.020215 0.3 4.02021517333 0.32 4.02021534667 0.34 4.02021552 0.36 4.02021569333 0.38
+ 4.02021586667 0.4 4.02021604 0.42 4.02021621333 0.44 4.02021638667 0.46 4.02021656 0.48 4.02021673333 0.5
+ 4.02021690667 0.52 4.02021708 0.54 4.02021725333 0.56 4.02021742667 0.58 4.0202176 0.6 4.02021777333 0.62
+ 4.02021794667 0.64 4.02021812 0.66 4.02021829333 0.68 4.02021846667 0.7 4.02021864 0.72 4.02021881333 0.74
+ 4.02021898667 0.76 4.02021916 0.78 4.02021933333 0.8 4.02021950667 0.82 4.02021968 0.84 4.02021985333 0.86
+ 4.02022002667 0.88 4.0202202 0.9 4.02022037333 0.92 4.02022054667 0.94 4.02022072 0.96 4.02022089333 0.98
+ 4.02022106667 1 4.02022124 1.02 4.02022141333 1.04 4.02022158667 1.06 4.02022176 1.08 4.02022193333 1.1
+ 4.02022210667 1.12 4.02022228 1.14 4.02022245333 1.16 4.02022262667 1.18 4.0202228 1.2 4.02022297333 1.22
+ 4.02022314667 1.24 4.02022332 1.26 4.02022349333 1.28 4.02022366667 1.3 4.02022384 1.32 4.02022401333 1.34
+ 4.02022418667 1.36 4.02022436 1.38 4.02022453333 1.4 4.02022470667 1.42 4.02022488 1.44 4.02022505333 1.46
+ 4.02022522667 1.48 4.0202254 1.5 4.02022557333 1.52 4.02022574667 1.54 4.02022592 1.56 4.02022609333 1.58
+ 4.02022626667 1.6 4.02022644 1.62 4.02022661333 1.64 4.02022678667 1.66 4.02022696 1.68 4.02022713333 1.7
+ 4.02022730667 1.72 4.02022748 1.74 4.02022765333 1.76 4.02022782667 1.78 4.020228 1.8 4.020229 0
+ 4.03031899 0 4.030318995 2.5 4.030328995 2.5 4.030329 0 6.030329 0 6.03033 -1.2
+ 6.03033017333 -1.18 6.03033034667 -1.16 6.03033052 -1.14 6.03033069333 -1.12 6.03033086667 -1.1 6.03033104 -1.08
+ 6.03033121333 -1.06 6.03033138667 -1.04 6.03033156 -1.02 6.03033173333 -1 6.03033190667 -0.98 6.03033208 -0.96
+ 6.03033225333 -0.94 6.03033242667 -0.92 6.0303326 -0.9 6.03033277333 -0.88 6.03033294667 -0.86 6.03033312 -0.84
+ 6.03033329333 -0.82 6.03033346667 -0.8 6.03033364 -0.78 6.03033381333 -0.76 6.03033398667 -0.74 6.03033416 -0.72
+ 6.03033433333 -0.7 6.03033450667 -0.68 6.03033468 -0.66 6.03033485333 -0.64 6.03033502667 -0.62 6.0303352 -0.6
+ 6.03033537333 -0.58 6.03033554667 -0.56 6.03033572 -0.54 6.03033589333 -0.52 6.03033606667 -0.5 6.03033624 -0.48
+ 6.03033641333 -0.46 6.03033658667 -0.44 6.03033676 -0.42 6.03033693333 -0.4 6.03033710667 -0.38 6.03033728 -0.36
+ 6.03033745333 -0.34 6.03033762667 -0.32 6.0303378 -0.3 6.03033797333 -0.28 6.03033814667 -0.26 6.03033832 -0.24
+ 6.03033849333 -0.22 6.03033866667 -0.2 6.03033884 -0.18 6.03033901333 -0.16 6.03033918667 -0.14 6.03033936 -0.12
+ 6.03033953333 -0.1 6.03033970667 -0.08 6.03033988 -0.06 6.03034005333 -0.04 6.03034022667 -0.02 6.0303404 0
+ 6.03034057333 0.02 6.03034074667 0.04 6.03034092 0.06 6.03034109333 0.08 6.03034126667 0.1 6.03034144 0.12
+ 6.03034161333 0.14 6.03034178667 0.16 6.03034196 0.18 6.03034213333 0.2 6.03034230667 0.22 6.03034248 0.24
+ 6.03034265333 0.26 6.03034282667 0.28 6.030343 0.3 6.03034317333 0.32 6.03034334667 0.34 6.03034352 0.36
+ 6.03034369333 0.38 6.03034386667 0.4 6.03034404 0.42 6.03034421333 0.44 6.03034438667 0.46 6.03034456 0.48
+ 6.03034473333 0.5 6.03034490667 0.52 6.03034508 0.54 6.03034525333 0.56 6.03034542667 0.58 6.0303456 0.6
+ 6.03034577333 0.62 6.03034594667 0.64 6.03034612 0.66 6.03034629333 0.68 6.03034646667 0.7 6.03034664 0.72
+ 6.03034681333 0.74 6.03034698667 0.76 6.03034716 0.78 6.03034733333 0.8 6.03034750667 0.82 6.03034768 0.84
+ 6.03034785333 0.86 6.03034802667 0.88 6.0303482 0.9 6.03034837333 0.92 6.03034854667 0.94 6.03034872 0.96
+ 6.03034889333 0.98 6.03034906667 1 6.03034924 1.02 6.03034941333 1.04 6.03034958667 1.06 6.03034976 1.08
+ 6.03034993333 1.1 6.03035010667 1.12 6.03035028 1.14 6.03035045333 1.16 6.03035062667 1.18 6.0303508 1.2
+ 6.03035097333 1.22 6.03035114667 1.24 6.03035132 1.26 6.03035149333 1.28 6.03035166667 1.3 6.03035184 1.32
+ 6.03035201333 1.34 6.03035218667 1.36 6.03035236 1.38 6.03035253333 1.4 6.03035270667 1.42 6.03035288 1.44
+ 6.03035305333 1.46 6.03035322667 1.48 6.0303534 1.5 6.03035357333 1.52 6.03035374667 1.54 6.03035392 1.56
+ 6.03035409333 1.58 6.03035426667 1.6 6.03035444 1.62 6.03035461333 1.64 6.03035478667 1.66 6.03035496 1.68
+ 6.03035513333 1.7 6.03035530667 1.72 6.03035548 1.74 6.03035565333 1.76 6.03035582667 1.78 6.030356 1.8
+ 6.030357 0)
Vd1 d1 0 pwl(
+ 0 0 4.0202004 0 4.0202005 0.05 4.0202291 0.05 4.0202292 0 6.0303284 0
+ 6.0303285 0.05 6.0303571 0.05 6.0303572 0)
X1 g1 d1 0 0 fefet_b16
Vg2 g2 0 pwl(
+ 0 0 0.01009099 0 0.010090995 3 0.010100995 3 0.010101 0 2.02019099 0
+ 2.020190995 -3 2.020200995 -3 2.020201 0 4.020201 0 4.020202 -1.2 4.02020217333 -1.18
+ 4.02020234667 -1.16 4.02020252 -1.14 4.02020269333 -1.12 4.02020286667 -1.1 4.02020304 -1.08 4.02020321333 -1.06
+ 4.02020338667 -1.04 4.02020356 -1.02 4.02020373333 -1 4.02020390667 -0.98 4.02020408 -0.96 4.02020425333 -0.94
+ 4.02020442667 -0.92 4.0202046 -0.9 4.02020477333 -0.88 4.02020494667 -0.86 4.02020512 -0.84 4.02020529333 -0.82
+ 4.02020546667 -0.8 4.02020564 -0.78 4.02020581333 -0.76 4.02020598667 -0.74 4.02020616 -0.72 4.02020633333 -0.7
+ 4.02020650667 -0.68 4.02020668 -0.66 4.02020685333 -0.64 4.02020702667 -0.62 4.0202072 -0.6 4.02020737333 -0.58
+ 4.02020754667 -0.56 4.02020772 -0.54 4.02020789333 -0.52 4.02020806667 -0.5 4.02020824 -0.48 4.02020841333 -0.46
+ 4.02020858667 -0.44 4.02020876 -0.42 4.02020893333 -0.4 4.02020910667 -0.38 4.02020928 -0.36 4.02020945333 -0.34
+ 4.02020962667 -0.32 4.0202098 -0.3 4.02020997333 -0.28 4.02021014667 -0.26 4.02021032 -0.24 4.02021049333 -0.22
+ 4.02021066667 -0.2 4.02021084 -0.18 4.02021101333 -0.16 4.02021118667 -0.14 4.02021136 -0.12 4.02021153333 -0.1
+ 4.02021170667 -0.08 4.02021188 -0.06 4.02021205333 -0.04 4.02021222667 -0.02 4.0202124 0 4.02021257333 0.02
+ 4.02021274667 0.04 4.02021292 0.06 4.02021309333 0.08 4.02021326667 0.1 4.02021344 0.12 4.02021361333 0.14
+ 4.02021378667 0.16 4.02021396 0.18 4.02021413333 0.2 4.02021430667 0.22 4.02021448 0.24 4.02021465333 0.26
+ 4.02021482667 0.28 4.020215 0.3 4.02021517333 0.32 4.02021534667 0.34 4.02021552 0.36 4.02021569333 0.38
+ 4.02021586667 0.4 4.02021604 0.42 4.02021621333 0.44 4.02021638667 0.46 4.02021656 0.48 4.02021673333 0.5
+ 4.02021690667 0.52 4.02021708 0.54 4.02021725333 0.56 4.02021742667 0.58 4.0202176 0.6 4.02021777333 0.62
+ 4.02021794667 0.64 4.02021812 0.66 4.02021829333 0.68 4.02021846667 0.7 4.02021864 0.72 4.02021881333 0.74
+ 4.02021898667 0.76 4.02021916 0.78 4.02021933333 0.8 4.02021950667 0.82 4.02021968 0.84 4.02021985333 0.86
+ 4.02022002667 0.88 4.0202202 0.9 4.02022037333 0.92 4.02022054667 0.94 4.02022072 0.96 4.02022089333 0.98
+ 4.02022106667 1 4.02022124 1.02 4.02022141333 1.04 4.02022158667 1.06 4.02022176 1.08 4.02022193333 1.1
+ 4.02022210667 1.12 4.02022228 1.14 4.02022245333 1.16 4.02022262667 1.18 4.0202228 1.2 4.02022297333 1.22
+ 4.02022314667 1.24 4.02022332 1.26 4.02022349333 1.28 4.02022366667 1.3 4.02022384 1.32 4.02022401333 1.34
+ 4.02022418667 1.36 4.02022436 1.38 4.02022453333 1.4 4.02022470667 1.42 4.02022488 1.44 4.02022505333 1.46
+ 4.02022522667 1.48 4.0202254 1.5 4.02022557333 1.52 4.02022574667 1.54 4.02022592 1.56 4.02022609333 1.58
+ 4.02022626667 1.6 4.02022644 1.62 4.02022661333 1.64 4.02022678667 1.66 4.02022696 1.68 4.02022713333 1.7
+ 4.02022730667 1.72 4.02022748 1.74 4.02022765333 1.76 4.02022782667 1.78 4.020228 1.8 4.020229 0
+ 4.03031899 0 4.030318995 3 4.030328995 3 4.030329 0 6.030329 0 6.03033 -1.2
+ 6.03033017333 -1.18 6.03033034667 -1.16 6.03033052 -1.14 6.03033069333 -1.12 6.03033086667 -1.1 6.03033104 -1.08
+ 6.03033121333 -1.06 6.03033138667 -1.04 6.03033156 -1.02 6.03033173333 -1 6.03033190667 -0.98 6.03033208 -0.96
+ 6.03033225333 -0.94 6.03033242667 -0.92 6.0303326 -0.9 6.03033277333 -0.88 6.03033294667 -0.86 6.03033312 -0.84
+ 6.03033329333 -0.82 6.03033346667 -0.8 6.03033364 -0.78 6.03033381333 -0.76 6.03033398667 -0.74 6.03033416 -0.72
+ 6.03033433333 -0.7 6.03033450667 -0.68 6.03033468 -0.66 6.03033485333 -0.64 6.03033502667 -0.62 6.0303352 -0.6
+ 6.03033537333 -0.58 6.03033554667 -0.56 6.03033572 -0.54 6.03033589333 -0.52 6.03033606667 -0.5 6.03033624 -0.48
+ 6.03033641333 -0.46 6.03033658667 -0.44 6.03033676 -0.42 6.03033693333 -0.4 6.03033710667 -0.38 6.03033728 -0.36
+ 6.03033745333 -0.34 6.03033762667 -0.32 6.0303378 -0.3 6.03033797333 -0.28 6.03033814667 -0.26 6.03033832 -0.24
+ 6.03033849333 -0.22 6.03033866667 -0.2 6.03033884 -0.18 6.03033901333 -0.16 6.03033918667 -0.14 6.03033936 -0.12
+ 6.03033953333 -0.1 6.03033970667 -0.08 6.03033988 -0.06 6.03034005333 -0.04 6.03034022667 -0.02 6.0303404 0
+ 6.03034057333 0.02 6.03034074667 0.04 6.03034092 0.06 6.03034109333 0.08 6.03034126667 0.1 6.03034144 0.12
+ 6.03034161333 0.14 6.03034178667 0.16 6.03034196 0.18 6.03034213333 0.2 6.03034230667 0.22 6.03034248 0.24
+ 6.03034265333 0.26 6.03034282667 0.28 6.030343 0.3 6.03034317333 0.32 6.03034334667 0.34 6.03034352 0.36
+ 6.03034369333 0.38 6.03034386667 0.4 6.03034404 0.42 6.03034421333 0.44 6.03034438667 0.46 6.03034456 0.48
+ 6.03034473333 0.5 6.03034490667 0.52 6.03034508 0.54 6.03034525333 0.56 6.03034542667 0.58 6.0303456 0.6
+ 6.03034577333 0.62 6.03034594667 0.64 6.03034612 0.66 6.03034629333 0.68 6.03034646667 0.7 6.03034664 0.72
+ 6.03034681333 0.74 6.03034698667 0.76 6.03034716 0.78 6.03034733333 0.8 6.03034750667 0.82 6.03034768 0.84
+ 6.03034785333 0.86 6.03034802667 0.88 6.0303482 0.9 6.03034837333 0.92 6.03034854667 0.94 6.03034872 0.96
+ 6.03034889333 0.98 6.03034906667 1 6.03034924 1.02 6.03034941333 1.04 6.03034958667 1.06 6.03034976 1.08
+ 6.03034993333 1.1 6.03035010667 1.12 6.03035028 1.14 6.03035045333 1.16 6.03035062667 1.18 6.0303508 1.2
+ 6.03035097333 1.22 6.03035114667 1.24 6.03035132 1.26 6.03035149333 1.28 6.03035166667 1.3 6.03035184 1.32
+ 6.03035201333 1.34 6.03035218667 1.36 6.03035236 1.38 6.03035253333 1.4 6.03035270667 1.42 6.03035288 1.44
+ 6.03035305333 1.46 6.03035322667 1.48 6.0303534 1.5 6.03035357333 1.52 6.03035374667 1.54 6.03035392 1.56
+ 6.03035409333 1.58 6.03035426667 1.6 6.03035444 1.62 6.03035461333 1.64 6.03035478667 1.66 6.03035496 1.68
+ 6.03035513333 1.7 6.03035530667 1.72 6.03035548 1.74 6.03035565333 1.76 6.03035582667 1.78 6.030356 1.8
+ 6.030357 0)
Vd2 d2 0 pwl(
+ 0 0 4.0202004 0 4.0202005 0.05 4.0202291 0.05 4.0202292 0 6.0303284 0
+ 6.0303285 0.05 6.0303571 0.05 6.0303572 0)
X2 g2 d2 0 0 fefet_b16
Vg3 g3 0 pwl(
+ 0 0 0.01009099 0 0.010090995 3.5 0.010100995 3.5 0.010101 0 2.02019099 0
+ 2.020190995 -3.5 2.020200995 -3.5 2.020201 0 4.020201 0 4.020202 -1.2 4.02020217333 -1.18
+ 4.02020234667 -1.16 4.02020252 -1.14 4.02020269333 -1.12 4.02020286667 -1.1 4.02020304 -1.08 4.02020321333 -1.06
+ 4.02020338667 -1.04 4.02020356 -1.02 4.02020373333 -1 4.02020390667 -0.98 4.02020408 -0.96 4.02020425333 -0.94
+ 4.02020442667 -0.92 4.0202046 -0.9 4.02020477333 -0.88 4.02020494667 -0.86 4.02020512 -0.84 4.02020529333 -0.82
+ 4.02020546667 -0.8 4.02020564 -0.78 4.02020581333 -0.76 4.02020598667 -0.74 4.02020616 -0.72 4.02020633333 -0.7
+ 4.02020650667 -0.68 4.02020668 -0.66 4.02020685333 -0.64 4.02020702667 -0.62 4.0202072 -0.6 4.02020737333 -0.58
+ 4.02020754667 -0.56 4.02020772 -0.54 4.02020789333 -0.52 4.02020806667 -0.5 4.02020824 -0.48 4.02020841333 -0.46
+ 4.02020858667 -0.44 4.02020876 -0.42 4.02020893333 -0.4 4.02020910667 -0.38 4.02020928 -0.36 4.02020945333 -0.34
+ 4.02020962667 -0.32 4.0202098 -0.3 4.02020997333 -0.28 4.02021014667 -0.26 4.02021032 -0.24 4.02021049333 -0.22
+ 4.02021066667 -0.2 4.02021084 -0.18 4.02021101333 -0.16 4.02021118667 -0.14 4.02021136 -0.12 4.02021153333 -0.1
+ 4.02021170667 -0.08 4.02021188 -0.06 4.02021205333 -0.04 4.02021222667 -0.02 4.0202124 0 4.02021257333 0.02
+ 4.02021274667 0.04 4.02021292 0.06 4.02021309333 0.08 4.02021326667 0.1 4.02021344 0.12 4.02021361333 0.14
+ 4.02021378667 0.16 4.02021396 0.18 4.02021413333 0.2 4.02021430667 0.22 4.02021448 0.24 4.02021465333 0.26
+ 4.02021482667 0.28 4.020215 0.3 4.02021517333 0.32 4.02021534667 0.34 4.02021552 0.36 4.02021569333 0.38
+ 4.02021586667 0.4 4.02021604 0.42 4.02021621333 0.44 4.02021638667 0.46 4.02021656 0.48 4.02021673333 0.5
+ 4.02021690667 0.52 4.02021708 0.54 4.02021725333 0.56 4.02021742667 0.58 4.0202176 0.6 4.02021777333 0.62
+ 4.02021794667 0.64 4.02021812 0.66 4.02021829333 0.68 4.02021846667 0.7 4.02021864 0.72 4.02021881333 0.74
+ 4.02021898667 0.76 4.02021916 0.78 4.02021933333 0.8 4.02021950667 0.82 4.02021968 0.84 4.02021985333 0.86
+ 4.02022002667 0.88 4.0202202 0.9 4.02022037333 0.92 4.02022054667 0.94 4.02022072 0.96 4.02022089333 0.98
+ 4.02022106667 1 4.02022124 1.02 4.02022141333 1.04 4.02022158667 1.06 4.02022176 1.08 4.02022193333 1.1
+ 4.02022210667 1.12 4.02022228 1.14 4.02022245333 1.16 4.02022262667 1.18 4.0202228 1.2 4.02022297333 1.22
+ 4.02022314667 1.24 4.02022332 1.26 4.02022349333 1.28 4.02022366667 1.3 4.02022384 1.32 4.02022401333 1.34
+ 4.02022418667 1.36 4.02022436 1.38 4.02022453333 1.4 4.02022470667 1.42 4.02022488 1.44 4.02022505333 1.46
+ 4.02022522667 1.48 4.0202254 1.5 4.02022557333 1.52 4.02022574667 1.54 4.02022592 1.56 4.02022609333 1.58
+ 4.02022626667 1.6 4.02022644 1.62 4.02022661333 1.64 4.02022678667 1.66 4.02022696 1.68 4.02022713333 1.7
+ 4.02022730667 1.72 4.02022748 1.74 4.02022765333 1.76 4.02022782667 1.78 4.020228 1.8 4.020229 0
+ 4.03031899 0 4.030318995 3.5 4.030328995 3.5 4.030329 0 6.030329 0 6.03033 -1.2
+ 6.03033017333 -1.18 6.03033034667 -1.16 6.03033052 -1.14 6.03033069333 -1.12 6.03033086667 -1.1 6.03033104 -1.08
+ 6.03033121333 -1.06 6.03033138667 -1.04 6.03033156 -1.02 6.03033173333 -1 6.03033190667 -0.98 6.03033208 -0.96
+ 6.03033225333 -0.94 6.03033242667 -0.92 6.0303326 -0.9 6.03033277333 -0.88 6.03033294667 -0.86 6.03033312 -0.84
+ 6.03033329333 -0.82 6.03033346667 -0.8 6.03033364 -0.78 6.03033381333 -0.76 6.03033398667 -0.74 6.03033416 -0.72
+ 6.03033433333 -0.7 6.03033450667 -0.68 6.03033468 -0.66 6.03033485333 -0.64 6.03033502667 -0.62 6.0303352 -0.6
+ 6.03033537333 -0.58 6.03033554667 -0.56 6.03033572 -0.54 6.03033589333 -0.52 6.03033606667 -0.5 6.03033624 -0.48
+ 6.03033641333 -0.46 6.03033658667 -0.44 6.03033676 -0.42 6.03033693333 -0.4 6.03033710667 -0.38 6.03033728 -0.36
+ 6.03033745333 -0.34 6.03033762667 -0.32 6.0303378 -0.3 6.03033797333 -0.28 6.03033814667 -0.26 6.03033832 -0.24
+ 6.03033849333 -0.22 6.03033866667 -0.2 6.03033884 -0.18 6.03033901333 -0.16 6.03033918667 -0.14 6.03033936 -0.12
+ 6.03033953333 -0.1 6.03033970667 -0.08 6.03033988 -0.06 6.03034005333 -0.04 6.03034022667 -0.02 6.0303404 0
+ 6.03034057333 0.02 6.03034074667 0.04 6.03034092 0.06 6.03034109333 0.08 6.03034126667 0.1 6.03034144 0.12
+ 6.03034161333 0.14 6.03034178667 0.16 6.03034196 0.18 6.03034213333 0.2 6.03034230667 0.22 6.03034248 0.24
+ 6.03034265333 0.26 6.03034282667 0.28 6.030343 0.3 6.03034317333 0.32 6.03034334667 0.34 6.03034352 0.36
+ 6.03034369333 0.38 6.03034386667 0.4 6.03034404 0.42 6.03034421333 0.44 6.03034438667 0.46 6.03034456 0.48
+ 6.03034473333 0.5 6.03034490667 0.52 6.03034508 0.54 6.03034525333 0.56 6.03034542667 0.58 6.0303456 0.6
+ 6.03034577333 0.62 6.03034594667 0.64 6.03034612 0.66 6.03034629333 0.68 6.03034646667 0.7 6.03034664 0.72
+ 6.03034681333 0.74 6.03034698667 0.76 6.03034716 0.78 6.03034733333 0.8 6.03034750667 0.82 6.03034768 0.84
+ 6.03034785333 0.86 6.03034802667 0.88 6.0303482 0.9 6.03034837333 0.92 6.03034854667 0.94 6.03034872 0.96
+ 6.03034889333 0.98 6.03034906667 1 6.03034924 1.02 6.03034941333 1.04 6.03034958667 1.06 6.03034976 1.08
+ 6.03034993333 1.1 6.03035010667 1.12 6.03035028 1.14 6.03035045333 1.16 6.03035062667 1.18 6.0303508 1.2
+ 6.03035097333 1.22 6.03035114667 1.24 6.03035132 1.26 6.03035149333 1.28 6.03035166667 1.3 6.03035184 1.32
+ 6.03035201333 1.34 6.03035218667 1.36 6.03035236 1.38 6.03035253333 1.4 6.03035270667 1.42 6.03035288 1.44
+ 6.03035305333 1.46 6.03035322667 1.48 6.0303534 1.5 6.03035357333 1.52 6.03035374667 1.54 6.03035392 1.56
+ 6.03035409333 1.58 6.03035426667 1.6 6.03035444 1.62 6.03035461333 1.64 6.03035478667 1.66 6.03035496 1.68
+ 6.03035513333 1.7 6.03035530667 1.72 6.03035548 1.74 6.03035565333 1.76 6.03035582667 1.78 6.030356 1.8
+ 6.030357 0)
Vd3 d3 0 pwl(
+ 0 0 4.0202004 0 4.0202005 0.05 4.0202291 0.05 4.0202292 0 6.0303284 0
+ 6.0303285 0.05 6.0303571 0.05 6.0303572 0)
X3 g3 d3 0 0 fefet_b16
Vg4 g4 0 pwl(
+ 0 0 0.01009099 0 0.010090995 4 0.010100995 4 0.010101 0 2.02019099 0
+ 2.020190995 -4 2.020200995 -4 2.020201 0 4.020201 0 4.020202 -1.2 4.02020217333 -1.18
+ 4.02020234667 -1.16 4.02020252 -1.14 4.02020269333 -1.12 4.02020286667 -1.1 4.02020304 -1.08 4.02020321333 -1.06
+ 4.02020338667 -1.04 4.02020356 -1.02 4.02020373333 -1 4.02020390667 -0.98 4.02020408 -0.96 4.02020425333 -0.94
+ 4.02020442667 -0.92 4.0202046 -0.9 4.02020477333 -0.88 4.02020494667 -0.86 4.02020512 -0.84 4.02020529333 -0.82
+ 4.02020546667 -0.8 4.02020564 -0.78 4.02020581333 -0.76 4.02020598667 -0.74 4.02020616 -0.72 4.02020633333 -0.7
+ 4.02020650667 -0.68 4.02020668 -0.66 4.02020685333 -0.64 4.02020702667 -0.62 4.0202072 -0.6 4.02020737333 -0.58
+ 4.02020754667 -0.56 4.02020772 -0.54 4.02020789333 -0.52 4.02020806667 -0.5 4.02020824 -0.48 4.02020841333 -0.46
+ 4.02020858667 -0.44 4.02020876 -0.42 4.02020893333 -0.4 4.02020910667 -0.38 4.02020928 -0.36 4.02020945333 -0.34
+ 4.02020962667 -0.32 4.0202098 -0.3 4.02020997333 -0.28 4.02021014667 -0.26 4.02021032 -0.24 4.02021049333 -0.22
+ 4.02021066667 -0.2 4.02021084 -0.18 4.02021101333 -0.16 4.02021118667 -0.14 4.02021136 -0.12 4.02021153333 -0.1
+ 4.02021170667 -0.08 4.02021188 -0.06 4.02021205333 -0.04 4.02021222667 -0.02 4.0202124 0 4.02021257333 0.02
+ 4.02021274667 0.04 4.02021292 0.06 4.02021309333 0.08 4.02021326667 0.1 4.02021344 0.12 4.02021361333 0.14
+ 4.02021378667 0.16 4.02021396 0.18 4.02021413333 0.2 4.02021430667 0.22 4.02021448 0.24 4.02021465333 0.26
+ 4.02021482667 0.28 4.020215 0.3 4.02021517333 0.32 4.02021534667 0.34 4.02021552 0.36 4.02021569333 0.38
+ 4.02021586667 0.4 4.02021604 0.42 4.02021621333 0.44 4.02021638667 0.46 4.02021656 0.48 4.02021673333 0.5
+ 4.02021690667 0.52 4.02021708 0.54 4.02021725333 0.56 4.02021742667 0.58 4.0202176 0.6 4.02021777333 0.62
+ 4.02021794667 0.64 4.02021812 0.66 4.02021829333 0.68 4.02021846667 0.7 4.02021864 0.72 4.02021881333 0.74
+ 4.02021898667 0.76 4.02021916 0.78 4.02021933333 0.8 4.02021950667 0.82 4.02021968 0.84 4.02021985333 0.86
+ 4.02022002667 0.88 4.0202202 0.9 4.02022037333 0.92 4.02022054667 0.94 4.02022072 0.96 4.02022089333 0.98
+ 4.02022106667 1 4.02022124 1.02 4.02022141333 1.04 4.02022158667 1.06 4.02022176 1.08 4.02022193333 1.1
+ 4.02022210667 1.12 4.02022228 1.14 4.02022245333 1.16 4.02022262667 1.18 4.0202228 1.2 4.02022297333 1.22
+ 4.02022314667 1.24 4.02022332 1.26 4.02022349333 1.28 4.02022366667 1.3 4.02022384 1.32 4.02022401333 1.34
+ 4.02022418667 1.36 4.02022436 1.38 4.02022453333 1.4 4.02022470667 1.42 4.02022488 1.44 4.02022505333 1.46
+ 4.02022522667 1.48 4.0202254 1.5 4.02022557333 1.52 4.02022574667 1.54 4.02022592 1.56 4.02022609333 1.58
+ 4.02022626667 1.6 4.02022644 1.62 4.02022661333 1.64 4.02022678667 1.66 4.02022696 1.68 4.02022713333 1.7
+ 4.02022730667 1.72 4.02022748 1.74 4.02022765333 1.76 4.02022782667 1.78 4.020228 1.8 4.020229 0
+ 4.03031899 0 4.030318995 4 4.030328995 4 4.030329 0 6.030329 0 6.03033 -1.2
+ 6.03033017333 -1.18 6.03033034667 -1.16 6.03033052 -1.14 6.03033069333 -1.12 6.03033086667 -1.1 6.03033104 -1.08
+ 6.03033121333 -1.06 6.03033138667 -1.04 6.03033156 -1.02 6.03033173333 -1 6.03033190667 -0.98 6.03033208 -0.96
+ 6.03033225333 -0.94 6.03033242667 -0.92 6.0303326 -0.9 6.03033277333 -0.88 6.03033294667 -0.86 6.03033312 -0.84
+ 6.03033329333 -0.82 6.03033346667 -0.8 6.03033364 -0.78 6.03033381333 -0.76 6.03033398667 -0.74 6.03033416 -0.72
+ 6.03033433333 -0.7 6.03033450667 -0.68 6.03033468 -0.66 6.03033485333 -0.64 6.03033502667 -0.62 6.0303352 -0.6
+ 6.03033537333 -0.58 6.03033554667 -0.56 6.03033572 -0.54 6.03033589333 -0.52 6.03033606667 -0.5 6.03033624 -0.48
+ 6.03033641333 -0.46 6.03033658667 -0.44 6.03033676 -0.42 6.03033693333 -0.4 6.03033710667 -0.38 6.03033728 -0.36
+ 6.03033745333 -0.34 6.03033762667 -0.32 6.0303378 -0.3 6.03033797333 -0.28 6.03033814667 -0.26 6.03033832 -0.24
+ 6.03033849333 -0.22 6.03033866667 -0.2 6.03033884 -0.18 6.03033901333 -0.16 6.03033918667 -0.14 6.03033936 -0.12
+ 6.03033953333 -0.1 6.03033970667 -0.08 6.03033988 -0.06 6.03034005333 -0.04 6.03034022667 -0.02 6.0303404 0
+ 6.03034057333 0.02 6.03034074667 0.04 6.03034092 0.06 6.03034109333 0.08 6.03034126667 0.1 6.03034144 0.12
+ 6.03034161333 0.14 6.03034178667 0.16 6.03034196 0.18 6.03034213333 0.2 6.03034230667 0.22 6.03034248 0.24
+ 6.03034265333 0.26 6.03034282667 0.28 6.030343 0.3 6.03034317333 0.32 6.03034334667 0.34 6.03034352 0.36
+ 6.03034369333 0.38 6.03034386667 0.4 6.03034404 0.42 6.03034421333 0.44 6.03034438667 0.46 6.03034456 0.48
+ 6.03034473333 0.5 6.03034490667 0.52 6.03034508 0.54 6.03034525333 0.56 6.03034542667 0.58 6.0303456 0.6
+ 6.03034577333 0.62 6.03034594667 0.64 6.03034612 0.66 6.03034629333 0.68 6.03034646667 0.7 6.03034664 0.72
+ 6.03034681333 0.74 6.03034698667 0.76 6.03034716 0.78 6.03034733333 0.8 6.03034750667 0.82 6.03034768 0.84
+ 6.03034785333 0.86 6.03034802667 0.88 6.0303482 0.9 6.03034837333 0.92 6.03034854667 0.94 6.03034872 0.96
+ 6.03034889333 0.98 6.03034906667 1 6.03034924 1.02 6.03034941333 1.04 6.03034958667 1.06 6.03034976 1.08
+ 6.03034993333 1.1 6.03035010667 1.12 6.03035028 1.14 6.03035045333 1.16 6.03035062667 1.18 6.0303508 1.2
+ 6.03035097333 1.22 6.03035114667 1.24 6.03035132 1.26 6.03035149333 1.28 6.03035166667 1.3 6.03035184 1.32
+ 6.03035201333 1.34 6.03035218667 1.36 6.03035236 1.38 6.03035253333 1.4 6.03035270667 1.42 6.03035288 1.44
+ 6.03035305333 1.46 6.03035322667 1.48 6.0303534 1.5 6.03035357333 1.52 6.03035374667 1.54 6.03035392 1.56
+ 6.03035409333 1.58 6.03035426667 1.6 6.03035444 1.62 6.03035461333 1.64 6.03035478667 1.66 6.03035496 1.68
+ 6.03035513333 1.7 6.03035530667 1.72 6.03035548 1.74 6.03035565333 1.76 6.03035582667 1.78 6.030356 1.8
+ 6.030357 0)
Vd4 d4 0 pwl(
+ 0 0 4.0202004 0 4.0202005 0.05 4.0202291 0.05 4.0202292 0 6.0303284 0
+ 6.0303285 0.05 6.0303571 0.05 6.0303572 0)
X4 g4 d4 0 0 fefet_b16
Vg5 g5 0 pwl(
+ 0 0 0.01009099 0 0.010090995 4.5 0.010100995 4.5 0.010101 0 2.02019099 0
+ 2.020190995 -4.5 2.020200995 -4.5 2.020201 0 4.020201 0 4.020202 -1.2 4.02020217333 -1.18
+ 4.02020234667 -1.16 4.02020252 -1.14 4.02020269333 -1.12 4.02020286667 -1.1 4.02020304 -1.08 4.02020321333 -1.06
+ 4.02020338667 -1.04 4.02020356 -1.02 4.02020373333 -1 4.02020390667 -0.98 4.02020408 -0.96 4.02020425333 -0.94
+ 4.02020442667 -0.92 4.0202046 -0.9 4.02020477333 -0.88 4.02020494667 -0.86 4.02020512 -0.84 4.02020529333 -0.82
+ 4.02020546667 -0.8 4.02020564 -0.78 4.02020581333 -0.76 4.02020598667 -0.74 4.02020616 -0.72 4.02020633333 -0.7
+ 4.02020650667 -0.68 4.02020668 -0.66 4.02020685333 -0.64 4.02020702667 -0.62 4.0202072 -0.6 4.02020737333 -0.58
+ 4.02020754667 -0.56 4.02020772 -0.54 4.02020789333 -0.52 4.02020806667 -0.5 4.02020824 -0.48 4.02020841333 -0.46
+ 4.02020858667 -0.44 4.02020876 -0.42 4.02020893333 -0.4 4.02020910667 -0.38 4.02020928 -0.36 4.02020945333 -0.34
+ 4.02020962667 -0.32 4.0202098 -0.3 4.02020997333 -0.28 4.02021014667 -0.26 4.02021032 -0.24 4.02021049333 -0.22
+ 4.02021066667 -0.2 4.02021084 -0.18 4.02021101333 -0.16 4.02021118667 -0.14 4.02021136 -0.12 4.02021153333 -0.1
+ 4.02021170667 -0.08 4.02021188 -0.06 4.02021205333 -0.04 4.02021222667 -0.02 4.0202124 0 4.02021257333 0.02
+ 4.02021274667 0.04 4.02021292 0.06 4.02021309333 0.08 4.02021326667 0.1 4.02021344 0.12 4.02021361333 0.14
+ 4.02021378667 0.16 4.02021396 0.18 4.02021413333 0.2 4.02021430667 0.22 4.02021448 0.24 4.02021465333 0.26
+ 4.02021482667 0.28 4.020215 0.3 4.02021517333 0.32 4.02021534667 0.34 4.02021552 0.36 4.02021569333 0.38
+ 4.02021586667 0.4 4.02021604 0.42 4.02021621333 0.44 4.02021638667 0.46 4.02021656 0.48 4.02021673333 0.5
+ 4.02021690667 0.52 4.02021708 0.54 4.02021725333 0.56 4.02021742667 0.58 4.0202176 0.6 4.02021777333 0.62
+ 4.02021794667 0.64 4.02021812 0.66 4.02021829333 0.68 4.02021846667 0.7 4.02021864 0.72 4.02021881333 0.74
+ 4.02021898667 0.76 4.02021916 0.78 4.02021933333 0.8 4.02021950667 0.82 4.02021968 0.84 4.02021985333 0.86
+ 4.02022002667 0.88 4.0202202 0.9 4.02022037333 0.92 4.02022054667 0.94 4.02022072 0.96 4.02022089333 0.98
+ 4.02022106667 1 4.02022124 1.02 4.02022141333 1.04 4.02022158667 1.06 4.02022176 1.08 4.02022193333 1.1
+ 4.02022210667 1.12 4.02022228 1.14 4.02022245333 1.16 4.02022262667 1.18 4.0202228 1.2 4.02022297333 1.22
+ 4.02022314667 1.24 4.02022332 1.26 4.02022349333 1.28 4.02022366667 1.3 4.02022384 1.32 4.02022401333 1.34
+ 4.02022418667 1.36 4.02022436 1.38 4.02022453333 1.4 4.02022470667 1.42 4.02022488 1.44 4.02022505333 1.46
+ 4.02022522667 1.48 4.0202254 1.5 4.02022557333 1.52 4.02022574667 1.54 4.02022592 1.56 4.02022609333 1.58
+ 4.02022626667 1.6 4.02022644 1.62 4.02022661333 1.64 4.02022678667 1.66 4.02022696 1.68 4.02022713333 1.7
+ 4.02022730667 1.72 4.02022748 1.74 4.02022765333 1.76 4.02022782667 1.78 4.020228 1.8 4.020229 0
+ 4.03031899 0 4.030318995 4.5 4.030328995 4.5 4.030329 0 6.030329 0 6.03033 -1.2
+ 6.03033017333 -1.18 6.03033034667 -1.16 6.03033052 -1.14 6.03033069333 -1.12 6.03033086667 -1.1 6.03033104 -1.08
+ 6.03033121333 -1.06 6.03033138667 -1.04 6.03033156 -1.02 6.03033173333 -1 6.03033190667 -0.98 6.03033208 -0.96
+ 6.03033225333 -0.94 6.03033242667 -0.92 6.0303326 -0.9 6.03033277333 -0.88 6.03033294667 -0.86 6.03033312 -0.84
+ 6.03033329333 -0.82 6.03033346667 -0.8 6.03033364 -0.78 6.03033381333 -0.76 6.03033398667 -0.74 6.03033416 -0.72
+ 6.03033433333 -0.7 6.03033450667 -0.68 6.03033468 -0.66 6.03033485333 -0.64 6.03033502667 -0.62 6.0303352 -0.6
+ 6.03033537333 -0.58 6.03033554667 -0.56 6.03033572 -0.54 6.03033589333 -0.52 6.03033606667 -0.5 6.03033624 -0.48
+ 6.03033641333 -0.46 6.03033658667 -0.44 6.03033676 -0.42 6.03033693333 -0.4 6.03033710667 -0.38 6.03033728 -0.36
+ 6.03033745333 -0.34 6.03033762667 -0.32 6.0303378 -0.3 6.03033797333 -0.28 6.03033814667 -0.26 6.03033832 -0.24
+ 6.03033849333 -0.22 6.03033866667 -0.2 6.03033884 -0.18 6.03033901333 -0.16 6.03033918667 -0.14 6.03033936 -0.12
+ 6.03033953333 -0.1 6.03033970667 -0.08 6.03033988 -0.06 6.03034005333 -0.04 6.03034022667 -0.02 6.0303404 0
+ 6.03034057333 0.02 6.03034074667 0.04 6.03034092 0.06 6.03034109333 0.08 6.03034126667 0.1 6.03034144 0.12
+ 6.03034161333 0.14 6.03034178667 0.16 6.03034196 0.18 6.03034213333 0.2 6.03034230667 0.22 6.03034248 0.24
+ 6.03034265333 0.26 6.03034282667 0.28 6.030343 0.3 6.03034317333 0.32 6.03034334667 0.34 6.03034352 0.36
+ 6.03034369333 0.38 6.03034386667 0.4 6.03034404 0.42 6.03034421333 0.44 6.03034438667 0.46 6.03034456 0.48
+ 6.03034473333 0.5 6.03034490667 0.52 6.03034508 0.54 6.03034525333 0.56 6.03034542667 0.58 6.0303456 0.6
+ 6.03034577333 0.62 6.03034594667 0.64 6.03034612 0.66 6.03034629333 0.68 6.03034646667 0.7 6.03034664 0.72
+ 6.03034681333 0.74 6.03034698667 0.76 6.03034716 0.78 6.03034733333 0.8 6.03034750667 0.82 6.03034768 0.84
+ 6.03034785333 0.86 6.03034802667 0.88 6.0303482 0.9 6.03034837333 0.92 6.03034854667 0.94 6.03034872 0.96
+ 6.03034889333 0.98 6.03034906667 1 6.03034924 1.02 6.03034941333 1.04 6.03034958667 1.06 6.03034976 1.08
+ 6.03034993333 1.1 6.03035010667 1.12 6.03035028 1.14 6.03035045333 1.16 6.03035062667 1.18 6.0303508 1.2
+ 6.03035097333 1.22 6.03035114667 1.24 6.03035132 1.26 6.03035149333 1.28 6.03035166667 1.3 6.03035184 1.32
+ 6.03035201333 1.34 6.03035218667 1.36 6.03035236 1.38 6.03035253333 1.4 6.03035270667 1.42 6.03035288 1.44
+ 6.03035305333 1.46 6.03035322667 1.48 6.0303534 1.5 6.03035357333 1.52 6.03035374667 1.54 6.03035392 1.56
+ 6.03035409333 1.58 6.03035426667 1.6 6.03035444 1.62 6.03035461333 1.64 6.03035478667 1.66 6.03035496 1.68
+ 6.03035513333 1.7 6.03035530667 1.72 6.03035548 1.74 6.03035565333 1.76 6.03035582667 1.78 6.030356 1.8
+ 6.030357 0)
Vd5 d5 0 pwl(
+ 0 0 4.0202004 0 4.0202005 0.05 4.0202291 0.05 4.0202292 0 6.0303284 0
+ 6.0303285 0.05 6.0303571 0.05 6.0303572 0)
X5 g5 d5 0 0 fefet_b16
.control
set wr_singlescale
set wr_vecnames
tran 1n 6.030358 0 0.0301518 uic
wrdata sim/out/t1d/t1d_w05.csv v(g0) i(vd0) v(g1) i(vd1) v(g2) i(vd2) v(g3) i(vd3)
+ v(g4) i(vd4) v(g5) i(vd5)
wrdata sim/out/t1d/t1d_w05_state.csv v(x5.xfe.x1) v(x5.xfe.x2) v(x5.xfe.x3) v(x5.xfe.x4) v(x5.xfe.x5) v(x5.xfe.x6) v(x5.xfe.x7) v(x5.xfe.x8)
+ v(x5.xfe.x9) v(x5.xfe.x10) v(x5.xfe.x11) v(x5.xfe.x12) v(x5.xfe.x13) v(x5.xfe.x14) v(x5.xfe.x15) v(x5.xfe.x16)
+ v(x5.m) v(g5)
.endc
.end
