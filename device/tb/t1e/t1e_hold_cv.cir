* t1e_hold_cv.cir -- generated by device/tb/make_t1e.py --stage 1
* Test 1e stage 1: hold one written FeFET for 1.1e+06 s: set C high V_th with +1.1 V on the gate until 100000 s (target C6), then 0 V.
* It starts from its state 2 s after the write.
.include ../../ngspice/fefet_preisach.lib
.options reltol=1e-3 abstol=1e-15 method=gear
Vbp bp 0 pwl(0 0 100 0 1000 0 10000 0 100000 0 100000.001 0 100002 0 1000000 0 1.1e+06 0)
Rbp bp 0 1k
Vc6 gc6 0 pwl(0 0 0.001 1.1 100000 1.1 100000.001 0 3.2e+08 0)
Xcv gc6 0 0 0 fefet_c16 x0_1=-1 x0_2=-1 x0_3=-1 x0_4=-1 x0_5=-1 x0_6=-1
+ x0_7=-1 x0_8=-1 x0_9=-1 x0_10=-1 x0_11=-1 x0_12=-1
+ x0_13=-1 x0_14=-1 x0_15=-1 x0_16=-1
.ic v(xcv.m)=-0.277154442
.control
save v(xcv.xfe.x1) v(xcv.xfe.x2) v(xcv.xfe.x3) v(xcv.xfe.x4) v(xcv.xfe.x5) v(xcv.xfe.x6) v(xcv.xfe.x7) v(xcv.xfe.x8)
+ v(xcv.xfe.x9) v(xcv.xfe.x10) v(xcv.xfe.x11) v(xcv.xfe.x12) v(xcv.xfe.x13) v(xcv.xfe.x14) v(xcv.xfe.x15) v(xcv.xfe.x16)
+ v(xcv.m)
set wr_singlescale
set wr_vecnames
tran 1n 1100000 0 5500 uic
wrdata sim/out/t1e/t1e_hold_cv.csv v(xcv.xfe.x1) v(xcv.xfe.x2) v(xcv.xfe.x3) v(xcv.xfe.x4) v(xcv.xfe.x5) v(xcv.xfe.x6) v(xcv.xfe.x7) v(xcv.xfe.x8)
+ v(xcv.xfe.x9) v(xcv.xfe.x10) v(xcv.xfe.x11) v(xcv.xfe.x12) v(xcv.xfe.x13) v(xcv.xfe.x14) v(xcv.xfe.x15) v(xcv.xfe.x16)
+ v(xcv.m)
.endc
.end
