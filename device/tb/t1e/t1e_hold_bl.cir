* t1e_hold_bl.cir -- generated by device/tb/make_t1e.py --stage 1
* Test 1e stage 1: hold one written FeFET for 1.1e+06 s: set B low V_th, all terminals at 0 V.
* It starts from its state 2 s after the write.
.include ../../ngspice/fefet_preisach.lib
.options reltol=1e-3 abstol=1e-15 method=gear
Vbp bp 0 pwl(0 0 100 0 1000 0 10000 0 100000 0 1000000 0 1.1e+06 0)
Rbp bp 0 1k
Xbl 0 0 0 0 fefet_b16 x0_1=-0.341292548 x0_2=0.208194509 x0_3=0.162299154 x0_4=0.115339993 x0_5=0.0795694638 x0_6=0.0529650001
+ x0_7=0.0333188505 x0_8=0.0190816686 x0_9=0.0091415946 x0_10=0.00264421728 x0_11=-0.00112288642 x0_12=-0.0027809821
+ x0_13=-0.00290573445 x0_14=-0.00206616267 x0_15=-0.000878958064 x0_16=-6.727301e-05
.ic v(xbl.m)=0.12347951
.control
save v(xbl.xfe.x1) v(xbl.xfe.x2) v(xbl.xfe.x3) v(xbl.xfe.x4) v(xbl.xfe.x5) v(xbl.xfe.x6) v(xbl.xfe.x7) v(xbl.xfe.x8)
+ v(xbl.xfe.x9) v(xbl.xfe.x10) v(xbl.xfe.x11) v(xbl.xfe.x12) v(xbl.xfe.x13) v(xbl.xfe.x14) v(xbl.xfe.x15) v(xbl.xfe.x16)
+ v(xbl.m)
set wr_singlescale
set wr_vecnames
tran 1n 1100000 0 5500 uic
wrdata sim/out/t1e/t1e_hold_bl.csv v(xbl.xfe.x1) v(xbl.xfe.x2) v(xbl.xfe.x3) v(xbl.xfe.x4) v(xbl.xfe.x5) v(xbl.xfe.x6) v(xbl.xfe.x7) v(xbl.xfe.x8)
+ v(xbl.xfe.x9) v(xbl.xfe.x10) v(xbl.xfe.x11) v(xbl.xfe.x12) v(xbl.xfe.x13) v(xbl.xfe.x14) v(xbl.xfe.x15) v(xbl.xfe.x16)
+ v(xbl.m)
.endc
.end
