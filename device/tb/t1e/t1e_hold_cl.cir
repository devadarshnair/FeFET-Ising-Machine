* t1e_hold_cl.cir -- generated by device/tb/make_t1e.py --stage 1
* Test 1e stage 1: hold one written FeFET for 1.1e+06 s: set C low V_th, all terminals at 0 V.
* It starts from its state 2 s after the write.
.include ../../ngspice/fefet_preisach.lib
.options reltol=1e-3 abstol=1e-15 method=gear
Vbp bp 0 pwl(0 0 100 0 1000 0 10000 0 100000 0 1000000 0 1.1e+06 0)
Rbp bp 0 1k
Xcl 0 0 0 0 fefet_c16 x0_1=1 x0_2=1 x0_3=1 x0_4=1 x0_5=1 x0_6=1
+ x0_7=1 x0_8=1 x0_9=1 x0_10=1 x0_11=1 x0_12=1
+ x0_13=1 x0_14=0.999999988 x0_15=1.00000021 x0_16=0.999959662
.ic v(xcl.m)=0.424804359
.control
save v(xcl.xfe.x1) v(xcl.xfe.x2) v(xcl.xfe.x3) v(xcl.xfe.x4) v(xcl.xfe.x5) v(xcl.xfe.x6) v(xcl.xfe.x7) v(xcl.xfe.x8)
+ v(xcl.xfe.x9) v(xcl.xfe.x10) v(xcl.xfe.x11) v(xcl.xfe.x12) v(xcl.xfe.x13) v(xcl.xfe.x14) v(xcl.xfe.x15) v(xcl.xfe.x16)
+ v(xcl.m)
set wr_singlescale
set wr_vecnames
tran 1n 1100000 0 5500 uic
wrdata sim/out/t1e/t1e_hold_cl.csv v(xcl.xfe.x1) v(xcl.xfe.x2) v(xcl.xfe.x3) v(xcl.xfe.x4) v(xcl.xfe.x5) v(xcl.xfe.x6) v(xcl.xfe.x7) v(xcl.xfe.x8)
+ v(xcl.xfe.x9) v(xcl.xfe.x10) v(xcl.xfe.x11) v(xcl.xfe.x12) v(xcl.xfe.x13) v(xcl.xfe.x14) v(xcl.xfe.x15) v(xcl.xfe.x16)
+ v(xcl.m)
.endc
.end
