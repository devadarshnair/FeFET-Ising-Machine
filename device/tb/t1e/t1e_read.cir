* t1e_read.cir -- generated by device/tb/make_t1e.py --stage 2
* Test 1e stage 2: read every held FeFET state once (a fresh instance started from
* the stage-1 state). Instance <dev><j>: j = index into HOLD_TIMES of make_t1e.py;
* cv0 = the C6 device at 100002 s.
.include ../../ngspice/fefet_preisach.lib
.options reltol=1e-4 abstol=1e-15 method=gear
Vg_bl0 g_bl0 0 pwl(
+ 0 0 1e-06 0 2e-06 -1.2 2.14444444444e-06 -1.18 2.28888888889e-06 -1.16 2.43333333333e-06 -1.14
+ 2.57777777778e-06 -1.12 2.72222222222e-06 -1.1 2.86666666667e-06 -1.08 3.01111111111e-06 -1.06 3.15555555556e-06 -1.04 3.3e-06 -1.02
+ 3.44444444444e-06 -1 3.58888888889e-06 -0.98 3.73333333333e-06 -0.96 3.87777777778e-06 -0.94 4.02222222222e-06 -0.92 4.16666666667e-06 -0.9
+ 4.31111111111e-06 -0.88 4.45555555556e-06 -0.86 4.6e-06 -0.84 4.74444444444e-06 -0.82 4.88888888889e-06 -0.8 5.03333333333e-06 -0.78
+ 5.17777777778e-06 -0.76 5.32222222222e-06 -0.74 5.46666666667e-06 -0.72 5.61111111111e-06 -0.7 5.75555555556e-06 -0.68 5.9e-06 -0.66
+ 6.04444444444e-06 -0.64 6.18888888889e-06 -0.62 6.33333333333e-06 -0.6 6.47777777778e-06 -0.58 6.62222222222e-06 -0.56 6.76666666667e-06 -0.54
+ 6.91111111111e-06 -0.52 7.05555555556e-06 -0.5 7.2e-06 -0.48 7.34444444444e-06 -0.46 7.48888888889e-06 -0.44 7.63333333333e-06 -0.42
+ 7.77777777778e-06 -0.4 7.92222222222e-06 -0.38 8.06666666667e-06 -0.36 8.21111111111e-06 -0.34 8.35555555556e-06 -0.32 8.5e-06 -0.3
+ 8.64444444444e-06 -0.28 8.78888888889e-06 -0.26 8.93333333333e-06 -0.24 9.07777777778e-06 -0.22 9.22222222222e-06 -0.2 9.36666666667e-06 -0.18
+ 9.51111111111e-06 -0.16 9.65555555556e-06 -0.14 9.8e-06 -0.12 9.94444444444e-06 -0.1 1.00888888889e-05 -0.08 1.02333333333e-05 -0.06
+ 1.03777777778e-05 -0.04 1.05222222222e-05 -0.02 1.06666666667e-05 -2.22045e-16 1.08111111111e-05 0.02 1.09555555556e-05 0.04 1.11e-05 0.06
+ 1.12444444444e-05 0.08 1.13888888889e-05 0.1 1.15333333333e-05 0.12 1.16777777778e-05 0.14 1.18222222222e-05 0.16 1.19666666667e-05 0.18
+ 1.21111111111e-05 0.2 1.22555555556e-05 0.22 1.24e-05 0.24 1.25444444444e-05 0.26 1.26888888889e-05 0.28 1.28333333333e-05 0.3
+ 1.29777777778e-05 0.32 1.31222222222e-05 0.34 1.32666666667e-05 0.36 1.34111111111e-05 0.38 1.35555555556e-05 0.4 1.37e-05 0.42
+ 1.38444444444e-05 0.44 1.39888888889e-05 0.46 1.41333333333e-05 0.48 1.42777777778e-05 0.5 1.44222222222e-05 0.52 1.45666666667e-05 0.54
+ 1.47111111111e-05 0.56 1.48555555556e-05 0.58 1.5e-05 0.6 1.51444444444e-05 0.62 1.52888888889e-05 0.64 1.54333333333e-05 0.66
+ 1.55777777778e-05 0.68 1.57222222222e-05 0.7 1.58666666667e-05 0.72 1.60111111111e-05 0.74 1.61555555556e-05 0.76 1.63e-05 0.78
+ 1.64444444444e-05 0.8 1.65888888889e-05 0.82 1.67333333333e-05 0.84 1.68777777778e-05 0.86 1.70222222222e-05 0.88 1.71666666667e-05 0.9
+ 1.73111111111e-05 0.92 1.74555555556e-05 0.94 1.76e-05 0.96 1.77444444444e-05 0.98 1.78888888889e-05 1 1.80333333333e-05 1.02
+ 1.81777777778e-05 1.04 1.83222222222e-05 1.06 1.84666666667e-05 1.08 1.86111111111e-05 1.1 1.87555555556e-05 1.12 1.89e-05 1.14
+ 1.90444444444e-05 1.16 1.91888888889e-05 1.18 1.93333333333e-05 1.2 1.94777777778e-05 1.22 1.96222222222e-05 1.24 1.97666666667e-05 1.26
+ 1.99111111111e-05 1.28 2.00555555556e-05 1.3 2.02e-05 1.32 2.03444444444e-05 1.34 2.04888888889e-05 1.36 2.06333333333e-05 1.38
+ 2.07777777778e-05 1.4 2.09222222222e-05 1.42 2.10666666667e-05 1.44 2.12111111111e-05 1.46 2.13555555556e-05 1.48 2.15e-05 1.5
+ 2.16444444444e-05 1.52 2.17888888889e-05 1.54 2.19333333333e-05 1.56 2.20777777778e-05 1.58 2.22222222222e-05 1.6 2.23666666667e-05 1.62
+ 2.25111111111e-05 1.64 2.26555555556e-05 1.66 2.28e-05 1.68 2.29444444444e-05 1.7 2.30888888889e-05 1.72 2.32333333333e-05 1.74
+ 2.33777777778e-05 1.76 2.35222222222e-05 1.78 2.36666666667e-05 1.8 2.38111111111e-05 1.82 2.39555555556e-05 1.84 2.41e-05 1.86
+ 2.42444444444e-05 1.88 2.43888888889e-05 1.9 2.45333333333e-05 1.92 2.46777777778e-05 1.94 2.48222222222e-05 1.96 2.49666666667e-05 1.98
+ 2.51111111111e-05 2 2.52555555556e-05 2.02 2.54e-05 2.04 2.55444444444e-05 2.06 2.56888888889e-05 2.08 2.58333333333e-05 2.1
+ 2.59777777778e-05 2.12 2.61222222222e-05 2.14 2.62666666667e-05 2.16 2.64111111111e-05 2.18 2.65555555556e-05 2.2 2.67e-05 2.22
+ 2.68444444444e-05 2.24 2.69888888889e-05 2.26 2.71333333333e-05 2.28 2.72777777778e-05 2.3 2.74222222222e-05 2.32 2.75666666667e-05 2.34
+ 2.77111111111e-05 2.36 2.78555555556e-05 2.38 2.8e-05 2.4 2.9e-05 0)
Vd_bl0 d_bl0 0 pwl(
+ 0 0 4e-07 0 5e-07 0.05 2.91e-05 0.05 2.92e-05 0)
Xbl0 g_bl0 d_bl0 0 0 fefet_b16 x0_1=-0.341292548 x0_2=0.208194509 x0_3=0.162299154 x0_4=0.115339993 x0_5=0.0795694638 x0_6=0.0529650001
+ x0_7=0.0333188505 x0_8=0.0190816686 x0_9=0.0091415946 x0_10=0.00264421728 x0_11=-0.00112288642 x0_12=-0.0027809821
+ x0_13=-0.00290573445 x0_14=-0.00206616267 x0_15=-0.000878958064 x0_16=-6.727301e-05
.ic v(xbl0.m)=0.12347951
Vg_bl1 g_bl1 0 pwl(
+ 0 0 1e-06 0 2e-06 -1.2 2.14444444444e-06 -1.18 2.28888888889e-06 -1.16 2.43333333333e-06 -1.14
+ 2.57777777778e-06 -1.12 2.72222222222e-06 -1.1 2.86666666667e-06 -1.08 3.01111111111e-06 -1.06 3.15555555556e-06 -1.04 3.3e-06 -1.02
+ 3.44444444444e-06 -1 3.58888888889e-06 -0.98 3.73333333333e-06 -0.96 3.87777777778e-06 -0.94 4.02222222222e-06 -0.92 4.16666666667e-06 -0.9
+ 4.31111111111e-06 -0.88 4.45555555556e-06 -0.86 4.6e-06 -0.84 4.74444444444e-06 -0.82 4.88888888889e-06 -0.8 5.03333333333e-06 -0.78
+ 5.17777777778e-06 -0.76 5.32222222222e-06 -0.74 5.46666666667e-06 -0.72 5.61111111111e-06 -0.7 5.75555555556e-06 -0.68 5.9e-06 -0.66
+ 6.04444444444e-06 -0.64 6.18888888889e-06 -0.62 6.33333333333e-06 -0.6 6.47777777778e-06 -0.58 6.62222222222e-06 -0.56 6.76666666667e-06 -0.54
+ 6.91111111111e-06 -0.52 7.05555555556e-06 -0.5 7.2e-06 -0.48 7.34444444444e-06 -0.46 7.48888888889e-06 -0.44 7.63333333333e-06 -0.42
+ 7.77777777778e-06 -0.4 7.92222222222e-06 -0.38 8.06666666667e-06 -0.36 8.21111111111e-06 -0.34 8.35555555556e-06 -0.32 8.5e-06 -0.3
+ 8.64444444444e-06 -0.28 8.78888888889e-06 -0.26 8.93333333333e-06 -0.24 9.07777777778e-06 -0.22 9.22222222222e-06 -0.2 9.36666666667e-06 -0.18
+ 9.51111111111e-06 -0.16 9.65555555556e-06 -0.14 9.8e-06 -0.12 9.94444444444e-06 -0.1 1.00888888889e-05 -0.08 1.02333333333e-05 -0.06
+ 1.03777777778e-05 -0.04 1.05222222222e-05 -0.02 1.06666666667e-05 -2.22045e-16 1.08111111111e-05 0.02 1.09555555556e-05 0.04 1.11e-05 0.06
+ 1.12444444444e-05 0.08 1.13888888889e-05 0.1 1.15333333333e-05 0.12 1.16777777778e-05 0.14 1.18222222222e-05 0.16 1.19666666667e-05 0.18
+ 1.21111111111e-05 0.2 1.22555555556e-05 0.22 1.24e-05 0.24 1.25444444444e-05 0.26 1.26888888889e-05 0.28 1.28333333333e-05 0.3
+ 1.29777777778e-05 0.32 1.31222222222e-05 0.34 1.32666666667e-05 0.36 1.34111111111e-05 0.38 1.35555555556e-05 0.4 1.37e-05 0.42
+ 1.38444444444e-05 0.44 1.39888888889e-05 0.46 1.41333333333e-05 0.48 1.42777777778e-05 0.5 1.44222222222e-05 0.52 1.45666666667e-05 0.54
+ 1.47111111111e-05 0.56 1.48555555556e-05 0.58 1.5e-05 0.6 1.51444444444e-05 0.62 1.52888888889e-05 0.64 1.54333333333e-05 0.66
+ 1.55777777778e-05 0.68 1.57222222222e-05 0.7 1.58666666667e-05 0.72 1.60111111111e-05 0.74 1.61555555556e-05 0.76 1.63e-05 0.78
+ 1.64444444444e-05 0.8 1.65888888889e-05 0.82 1.67333333333e-05 0.84 1.68777777778e-05 0.86 1.70222222222e-05 0.88 1.71666666667e-05 0.9
+ 1.73111111111e-05 0.92 1.74555555556e-05 0.94 1.76e-05 0.96 1.77444444444e-05 0.98 1.78888888889e-05 1 1.80333333333e-05 1.02
+ 1.81777777778e-05 1.04 1.83222222222e-05 1.06 1.84666666667e-05 1.08 1.86111111111e-05 1.1 1.87555555556e-05 1.12 1.89e-05 1.14
+ 1.90444444444e-05 1.16 1.91888888889e-05 1.18 1.93333333333e-05 1.2 1.94777777778e-05 1.22 1.96222222222e-05 1.24 1.97666666667e-05 1.26
+ 1.99111111111e-05 1.28 2.00555555556e-05 1.3 2.02e-05 1.32 2.03444444444e-05 1.34 2.04888888889e-05 1.36 2.06333333333e-05 1.38
+ 2.07777777778e-05 1.4 2.09222222222e-05 1.42 2.10666666667e-05 1.44 2.12111111111e-05 1.46 2.13555555556e-05 1.48 2.15e-05 1.5
+ 2.16444444444e-05 1.52 2.17888888889e-05 1.54 2.19333333333e-05 1.56 2.20777777778e-05 1.58 2.22222222222e-05 1.6 2.23666666667e-05 1.62
+ 2.25111111111e-05 1.64 2.26555555556e-05 1.66 2.28e-05 1.68 2.29444444444e-05 1.7 2.30888888889e-05 1.72 2.32333333333e-05 1.74
+ 2.33777777778e-05 1.76 2.35222222222e-05 1.78 2.36666666667e-05 1.8 2.38111111111e-05 1.82 2.39555555556e-05 1.84 2.41e-05 1.86
+ 2.42444444444e-05 1.88 2.43888888889e-05 1.9 2.45333333333e-05 1.92 2.46777777778e-05 1.94 2.48222222222e-05 1.96 2.49666666667e-05 1.98
+ 2.51111111111e-05 2 2.52555555556e-05 2.02 2.54e-05 2.04 2.55444444444e-05 2.06 2.56888888889e-05 2.08 2.58333333333e-05 2.1
+ 2.59777777778e-05 2.12 2.61222222222e-05 2.14 2.62666666667e-05 2.16 2.64111111111e-05 2.18 2.65555555556e-05 2.2 2.67e-05 2.22
+ 2.68444444444e-05 2.24 2.69888888889e-05 2.26 2.71333333333e-05 2.28 2.72777777778e-05 2.3 2.74222222222e-05 2.32 2.75666666667e-05 2.34
+ 2.77111111111e-05 2.36 2.78555555556e-05 2.38 2.8e-05 2.4 2.9e-05 0)
Vd_bl1 d_bl1 0 pwl(
+ 0 0 4e-07 0 5e-07 0.05 2.91e-05 0.05 2.92e-05 0)
Xbl1 g_bl1 d_bl1 0 0 fefet_b16 x0_1=-0.394324955 x0_2=0.208194432 x0_3=0.162299154 x0_4=0.115339993 x0_5=0.0795694638 x0_6=0.0529650001
+ x0_7=0.0333188505 x0_8=0.0190816686 x0_9=0.0091415946 x0_10=0.00264421728 x0_11=-0.00112288642 x0_12=-0.0027809821
+ x0_13=-0.00290573445 x0_14=-0.00206616267 x0_15=-0.000878958064 x0_16=-6.727301e-05
.ic v(xbl1.m)=0.103834677
Vg_bl2 g_bl2 0 pwl(
+ 0 0 1e-06 0 2e-06 -1.2 2.14444444444e-06 -1.18 2.28888888889e-06 -1.16 2.43333333333e-06 -1.14
+ 2.57777777778e-06 -1.12 2.72222222222e-06 -1.1 2.86666666667e-06 -1.08 3.01111111111e-06 -1.06 3.15555555556e-06 -1.04 3.3e-06 -1.02
+ 3.44444444444e-06 -1 3.58888888889e-06 -0.98 3.73333333333e-06 -0.96 3.87777777778e-06 -0.94 4.02222222222e-06 -0.92 4.16666666667e-06 -0.9
+ 4.31111111111e-06 -0.88 4.45555555556e-06 -0.86 4.6e-06 -0.84 4.74444444444e-06 -0.82 4.88888888889e-06 -0.8 5.03333333333e-06 -0.78
+ 5.17777777778e-06 -0.76 5.32222222222e-06 -0.74 5.46666666667e-06 -0.72 5.61111111111e-06 -0.7 5.75555555556e-06 -0.68 5.9e-06 -0.66
+ 6.04444444444e-06 -0.64 6.18888888889e-06 -0.62 6.33333333333e-06 -0.6 6.47777777778e-06 -0.58 6.62222222222e-06 -0.56 6.76666666667e-06 -0.54
+ 6.91111111111e-06 -0.52 7.05555555556e-06 -0.5 7.2e-06 -0.48 7.34444444444e-06 -0.46 7.48888888889e-06 -0.44 7.63333333333e-06 -0.42
+ 7.77777777778e-06 -0.4 7.92222222222e-06 -0.38 8.06666666667e-06 -0.36 8.21111111111e-06 -0.34 8.35555555556e-06 -0.32 8.5e-06 -0.3
+ 8.64444444444e-06 -0.28 8.78888888889e-06 -0.26 8.93333333333e-06 -0.24 9.07777777778e-06 -0.22 9.22222222222e-06 -0.2 9.36666666667e-06 -0.18
+ 9.51111111111e-06 -0.16 9.65555555556e-06 -0.14 9.8e-06 -0.12 9.94444444444e-06 -0.1 1.00888888889e-05 -0.08 1.02333333333e-05 -0.06
+ 1.03777777778e-05 -0.04 1.05222222222e-05 -0.02 1.06666666667e-05 -2.22045e-16 1.08111111111e-05 0.02 1.09555555556e-05 0.04 1.11e-05 0.06
+ 1.12444444444e-05 0.08 1.13888888889e-05 0.1 1.15333333333e-05 0.12 1.16777777778e-05 0.14 1.18222222222e-05 0.16 1.19666666667e-05 0.18
+ 1.21111111111e-05 0.2 1.22555555556e-05 0.22 1.24e-05 0.24 1.25444444444e-05 0.26 1.26888888889e-05 0.28 1.28333333333e-05 0.3
+ 1.29777777778e-05 0.32 1.31222222222e-05 0.34 1.32666666667e-05 0.36 1.34111111111e-05 0.38 1.35555555556e-05 0.4 1.37e-05 0.42
+ 1.38444444444e-05 0.44 1.39888888889e-05 0.46 1.41333333333e-05 0.48 1.42777777778e-05 0.5 1.44222222222e-05 0.52 1.45666666667e-05 0.54
+ 1.47111111111e-05 0.56 1.48555555556e-05 0.58 1.5e-05 0.6 1.51444444444e-05 0.62 1.52888888889e-05 0.64 1.54333333333e-05 0.66
+ 1.55777777778e-05 0.68 1.57222222222e-05 0.7 1.58666666667e-05 0.72 1.60111111111e-05 0.74 1.61555555556e-05 0.76 1.63e-05 0.78
+ 1.64444444444e-05 0.8 1.65888888889e-05 0.82 1.67333333333e-05 0.84 1.68777777778e-05 0.86 1.70222222222e-05 0.88 1.71666666667e-05 0.9
+ 1.73111111111e-05 0.92 1.74555555556e-05 0.94 1.76e-05 0.96 1.77444444444e-05 0.98 1.78888888889e-05 1 1.80333333333e-05 1.02
+ 1.81777777778e-05 1.04 1.83222222222e-05 1.06 1.84666666667e-05 1.08 1.86111111111e-05 1.1 1.87555555556e-05 1.12 1.89e-05 1.14
+ 1.90444444444e-05 1.16 1.91888888889e-05 1.18 1.93333333333e-05 1.2 1.94777777778e-05 1.22 1.96222222222e-05 1.24 1.97666666667e-05 1.26
+ 1.99111111111e-05 1.28 2.00555555556e-05 1.3 2.02e-05 1.32 2.03444444444e-05 1.34 2.04888888889e-05 1.36 2.06333333333e-05 1.38
+ 2.07777777778e-05 1.4 2.09222222222e-05 1.42 2.10666666667e-05 1.44 2.12111111111e-05 1.46 2.13555555556e-05 1.48 2.15e-05 1.5
+ 2.16444444444e-05 1.52 2.17888888889e-05 1.54 2.19333333333e-05 1.56 2.20777777778e-05 1.58 2.22222222222e-05 1.6 2.23666666667e-05 1.62
+ 2.25111111111e-05 1.64 2.26555555556e-05 1.66 2.28e-05 1.68 2.29444444444e-05 1.7 2.30888888889e-05 1.72 2.32333333333e-05 1.74
+ 2.33777777778e-05 1.76 2.35222222222e-05 1.78 2.36666666667e-05 1.8 2.38111111111e-05 1.82 2.39555555556e-05 1.84 2.41e-05 1.86
+ 2.42444444444e-05 1.88 2.43888888889e-05 1.9 2.45333333333e-05 1.92 2.46777777778e-05 1.94 2.48222222222e-05 1.96 2.49666666667e-05 1.98
+ 2.51111111111e-05 2 2.52555555556e-05 2.02 2.54e-05 2.04 2.55444444444e-05 2.06 2.56888888889e-05 2.08 2.58333333333e-05 2.1
+ 2.59777777778e-05 2.12 2.61222222222e-05 2.14 2.62666666667e-05 2.16 2.64111111111e-05 2.18 2.65555555556e-05 2.2 2.67e-05 2.22
+ 2.68444444444e-05 2.24 2.69888888889e-05 2.26 2.71333333333e-05 2.28 2.72777777778e-05 2.3 2.74222222222e-05 2.32 2.75666666667e-05 2.34
+ 2.77111111111e-05 2.36 2.78555555556e-05 2.38 2.8e-05 2.4 2.9e-05 0)
Vd_bl2 d_bl2 0 pwl(
+ 0 0 4e-07 0 5e-07 0.05 2.91e-05 0.05 2.92e-05 0)
Xbl2 g_bl2 d_bl2 0 0 fefet_b16 x0_1=-0.418767915 x0_2=0.20819443 x0_3=0.162299154 x0_4=0.115339993 x0_5=0.0795694638 x0_6=0.0529650001
+ x0_7=0.0333188505 x0_8=0.0190816686 x0_9=0.0091415946 x0_10=0.00264421728 x0_11=-0.00112288642 x0_12=-0.0027809821
+ x0_13=-0.00290573445 x0_14=-0.00206616267 x0_15=-0.000878958064 x0_16=-6.727301e-05
.ic v(xbl2.m)=0.0947493078
Vg_bl3 g_bl3 0 pwl(
+ 0 0 1e-06 0 2e-06 -1.2 2.14444444444e-06 -1.18 2.28888888889e-06 -1.16 2.43333333333e-06 -1.14
+ 2.57777777778e-06 -1.12 2.72222222222e-06 -1.1 2.86666666667e-06 -1.08 3.01111111111e-06 -1.06 3.15555555556e-06 -1.04 3.3e-06 -1.02
+ 3.44444444444e-06 -1 3.58888888889e-06 -0.98 3.73333333333e-06 -0.96 3.87777777778e-06 -0.94 4.02222222222e-06 -0.92 4.16666666667e-06 -0.9
+ 4.31111111111e-06 -0.88 4.45555555556e-06 -0.86 4.6e-06 -0.84 4.74444444444e-06 -0.82 4.88888888889e-06 -0.8 5.03333333333e-06 -0.78
+ 5.17777777778e-06 -0.76 5.32222222222e-06 -0.74 5.46666666667e-06 -0.72 5.61111111111e-06 -0.7 5.75555555556e-06 -0.68 5.9e-06 -0.66
+ 6.04444444444e-06 -0.64 6.18888888889e-06 -0.62 6.33333333333e-06 -0.6 6.47777777778e-06 -0.58 6.62222222222e-06 -0.56 6.76666666667e-06 -0.54
+ 6.91111111111e-06 -0.52 7.05555555556e-06 -0.5 7.2e-06 -0.48 7.34444444444e-06 -0.46 7.48888888889e-06 -0.44 7.63333333333e-06 -0.42
+ 7.77777777778e-06 -0.4 7.92222222222e-06 -0.38 8.06666666667e-06 -0.36 8.21111111111e-06 -0.34 8.35555555556e-06 -0.32 8.5e-06 -0.3
+ 8.64444444444e-06 -0.28 8.78888888889e-06 -0.26 8.93333333333e-06 -0.24 9.07777777778e-06 -0.22 9.22222222222e-06 -0.2 9.36666666667e-06 -0.18
+ 9.51111111111e-06 -0.16 9.65555555556e-06 -0.14 9.8e-06 -0.12 9.94444444444e-06 -0.1 1.00888888889e-05 -0.08 1.02333333333e-05 -0.06
+ 1.03777777778e-05 -0.04 1.05222222222e-05 -0.02 1.06666666667e-05 -2.22045e-16 1.08111111111e-05 0.02 1.09555555556e-05 0.04 1.11e-05 0.06
+ 1.12444444444e-05 0.08 1.13888888889e-05 0.1 1.15333333333e-05 0.12 1.16777777778e-05 0.14 1.18222222222e-05 0.16 1.19666666667e-05 0.18
+ 1.21111111111e-05 0.2 1.22555555556e-05 0.22 1.24e-05 0.24 1.25444444444e-05 0.26 1.26888888889e-05 0.28 1.28333333333e-05 0.3
+ 1.29777777778e-05 0.32 1.31222222222e-05 0.34 1.32666666667e-05 0.36 1.34111111111e-05 0.38 1.35555555556e-05 0.4 1.37e-05 0.42
+ 1.38444444444e-05 0.44 1.39888888889e-05 0.46 1.41333333333e-05 0.48 1.42777777778e-05 0.5 1.44222222222e-05 0.52 1.45666666667e-05 0.54
+ 1.47111111111e-05 0.56 1.48555555556e-05 0.58 1.5e-05 0.6 1.51444444444e-05 0.62 1.52888888889e-05 0.64 1.54333333333e-05 0.66
+ 1.55777777778e-05 0.68 1.57222222222e-05 0.7 1.58666666667e-05 0.72 1.60111111111e-05 0.74 1.61555555556e-05 0.76 1.63e-05 0.78
+ 1.64444444444e-05 0.8 1.65888888889e-05 0.82 1.67333333333e-05 0.84 1.68777777778e-05 0.86 1.70222222222e-05 0.88 1.71666666667e-05 0.9
+ 1.73111111111e-05 0.92 1.74555555556e-05 0.94 1.76e-05 0.96 1.77444444444e-05 0.98 1.78888888889e-05 1 1.80333333333e-05 1.02
+ 1.81777777778e-05 1.04 1.83222222222e-05 1.06 1.84666666667e-05 1.08 1.86111111111e-05 1.1 1.87555555556e-05 1.12 1.89e-05 1.14
+ 1.90444444444e-05 1.16 1.91888888889e-05 1.18 1.93333333333e-05 1.2 1.94777777778e-05 1.22 1.96222222222e-05 1.24 1.97666666667e-05 1.26
+ 1.99111111111e-05 1.28 2.00555555556e-05 1.3 2.02e-05 1.32 2.03444444444e-05 1.34 2.04888888889e-05 1.36 2.06333333333e-05 1.38
+ 2.07777777778e-05 1.4 2.09222222222e-05 1.42 2.10666666667e-05 1.44 2.12111111111e-05 1.46 2.13555555556e-05 1.48 2.15e-05 1.5
+ 2.16444444444e-05 1.52 2.17888888889e-05 1.54 2.19333333333e-05 1.56 2.20777777778e-05 1.58 2.22222222222e-05 1.6 2.23666666667e-05 1.62
+ 2.25111111111e-05 1.64 2.26555555556e-05 1.66 2.28e-05 1.68 2.29444444444e-05 1.7 2.30888888889e-05 1.72 2.32333333333e-05 1.74
+ 2.33777777778e-05 1.76 2.35222222222e-05 1.78 2.36666666667e-05 1.8 2.38111111111e-05 1.82 2.39555555556e-05 1.84 2.41e-05 1.86
+ 2.42444444444e-05 1.88 2.43888888889e-05 1.9 2.45333333333e-05 1.92 2.46777777778e-05 1.94 2.48222222222e-05 1.96 2.49666666667e-05 1.98
+ 2.51111111111e-05 2 2.52555555556e-05 2.02 2.54e-05 2.04 2.55444444444e-05 2.06 2.56888888889e-05 2.08 2.58333333333e-05 2.1
+ 2.59777777778e-05 2.12 2.61222222222e-05 2.14 2.62666666667e-05 2.16 2.64111111111e-05 2.18 2.65555555556e-05 2.2 2.67e-05 2.22
+ 2.68444444444e-05 2.24 2.69888888889e-05 2.26 2.71333333333e-05 2.28 2.72777777778e-05 2.3 2.74222222222e-05 2.32 2.75666666667e-05 2.34
+ 2.77111111111e-05 2.36 2.78555555556e-05 2.38 2.8e-05 2.4 2.9e-05 0)
Vd_bl3 d_bl3 0 pwl(
+ 0 0 4e-07 0 5e-07 0.05 2.91e-05 0.05 2.92e-05 0)
Xbl3 g_bl3 d_bl3 0 0 fefet_b16 x0_1=-0.440204314 x0_2=0.20819443 x0_3=0.162299154 x0_4=0.115339993 x0_5=0.0795694638 x0_6=0.0529650001
+ x0_7=0.0333188505 x0_8=0.0190816686 x0_9=0.0091415946 x0_10=0.00264421728 x0_11=-0.00112288642 x0_12=-0.0027809821
+ x0_13=-0.00290573445 x0_14=-0.00206616267 x0_15=-0.000878958064 x0_16=-6.727301e-05
.ic v(xbl3.m)=0.0867707114
Vg_bl4 g_bl4 0 pwl(
+ 0 0 1e-06 0 2e-06 -1.2 2.14444444444e-06 -1.18 2.28888888889e-06 -1.16 2.43333333333e-06 -1.14
+ 2.57777777778e-06 -1.12 2.72222222222e-06 -1.1 2.86666666667e-06 -1.08 3.01111111111e-06 -1.06 3.15555555556e-06 -1.04 3.3e-06 -1.02
+ 3.44444444444e-06 -1 3.58888888889e-06 -0.98 3.73333333333e-06 -0.96 3.87777777778e-06 -0.94 4.02222222222e-06 -0.92 4.16666666667e-06 -0.9
+ 4.31111111111e-06 -0.88 4.45555555556e-06 -0.86 4.6e-06 -0.84 4.74444444444e-06 -0.82 4.88888888889e-06 -0.8 5.03333333333e-06 -0.78
+ 5.17777777778e-06 -0.76 5.32222222222e-06 -0.74 5.46666666667e-06 -0.72 5.61111111111e-06 -0.7 5.75555555556e-06 -0.68 5.9e-06 -0.66
+ 6.04444444444e-06 -0.64 6.18888888889e-06 -0.62 6.33333333333e-06 -0.6 6.47777777778e-06 -0.58 6.62222222222e-06 -0.56 6.76666666667e-06 -0.54
+ 6.91111111111e-06 -0.52 7.05555555556e-06 -0.5 7.2e-06 -0.48 7.34444444444e-06 -0.46 7.48888888889e-06 -0.44 7.63333333333e-06 -0.42
+ 7.77777777778e-06 -0.4 7.92222222222e-06 -0.38 8.06666666667e-06 -0.36 8.21111111111e-06 -0.34 8.35555555556e-06 -0.32 8.5e-06 -0.3
+ 8.64444444444e-06 -0.28 8.78888888889e-06 -0.26 8.93333333333e-06 -0.24 9.07777777778e-06 -0.22 9.22222222222e-06 -0.2 9.36666666667e-06 -0.18
+ 9.51111111111e-06 -0.16 9.65555555556e-06 -0.14 9.8e-06 -0.12 9.94444444444e-06 -0.1 1.00888888889e-05 -0.08 1.02333333333e-05 -0.06
+ 1.03777777778e-05 -0.04 1.05222222222e-05 -0.02 1.06666666667e-05 -2.22045e-16 1.08111111111e-05 0.02 1.09555555556e-05 0.04 1.11e-05 0.06
+ 1.12444444444e-05 0.08 1.13888888889e-05 0.1 1.15333333333e-05 0.12 1.16777777778e-05 0.14 1.18222222222e-05 0.16 1.19666666667e-05 0.18
+ 1.21111111111e-05 0.2 1.22555555556e-05 0.22 1.24e-05 0.24 1.25444444444e-05 0.26 1.26888888889e-05 0.28 1.28333333333e-05 0.3
+ 1.29777777778e-05 0.32 1.31222222222e-05 0.34 1.32666666667e-05 0.36 1.34111111111e-05 0.38 1.35555555556e-05 0.4 1.37e-05 0.42
+ 1.38444444444e-05 0.44 1.39888888889e-05 0.46 1.41333333333e-05 0.48 1.42777777778e-05 0.5 1.44222222222e-05 0.52 1.45666666667e-05 0.54
+ 1.47111111111e-05 0.56 1.48555555556e-05 0.58 1.5e-05 0.6 1.51444444444e-05 0.62 1.52888888889e-05 0.64 1.54333333333e-05 0.66
+ 1.55777777778e-05 0.68 1.57222222222e-05 0.7 1.58666666667e-05 0.72 1.60111111111e-05 0.74 1.61555555556e-05 0.76 1.63e-05 0.78
+ 1.64444444444e-05 0.8 1.65888888889e-05 0.82 1.67333333333e-05 0.84 1.68777777778e-05 0.86 1.70222222222e-05 0.88 1.71666666667e-05 0.9
+ 1.73111111111e-05 0.92 1.74555555556e-05 0.94 1.76e-05 0.96 1.77444444444e-05 0.98 1.78888888889e-05 1 1.80333333333e-05 1.02
+ 1.81777777778e-05 1.04 1.83222222222e-05 1.06 1.84666666667e-05 1.08 1.86111111111e-05 1.1 1.87555555556e-05 1.12 1.89e-05 1.14
+ 1.90444444444e-05 1.16 1.91888888889e-05 1.18 1.93333333333e-05 1.2 1.94777777778e-05 1.22 1.96222222222e-05 1.24 1.97666666667e-05 1.26
+ 1.99111111111e-05 1.28 2.00555555556e-05 1.3 2.02e-05 1.32 2.03444444444e-05 1.34 2.04888888889e-05 1.36 2.06333333333e-05 1.38
+ 2.07777777778e-05 1.4 2.09222222222e-05 1.42 2.10666666667e-05 1.44 2.12111111111e-05 1.46 2.13555555556e-05 1.48 2.15e-05 1.5
+ 2.16444444444e-05 1.52 2.17888888889e-05 1.54 2.19333333333e-05 1.56 2.20777777778e-05 1.58 2.22222222222e-05 1.6 2.23666666667e-05 1.62
+ 2.25111111111e-05 1.64 2.26555555556e-05 1.66 2.28e-05 1.68 2.29444444444e-05 1.7 2.30888888889e-05 1.72 2.32333333333e-05 1.74
+ 2.33777777778e-05 1.76 2.35222222222e-05 1.78 2.36666666667e-05 1.8 2.38111111111e-05 1.82 2.39555555556e-05 1.84 2.41e-05 1.86
+ 2.42444444444e-05 1.88 2.43888888889e-05 1.9 2.45333333333e-05 1.92 2.46777777778e-05 1.94 2.48222222222e-05 1.96 2.49666666667e-05 1.98
+ 2.51111111111e-05 2 2.52555555556e-05 2.02 2.54e-05 2.04 2.55444444444e-05 2.06 2.56888888889e-05 2.08 2.58333333333e-05 2.1
+ 2.59777777778e-05 2.12 2.61222222222e-05 2.14 2.62666666667e-05 2.16 2.64111111111e-05 2.18 2.65555555556e-05 2.2 2.67e-05 2.22
+ 2.68444444444e-05 2.24 2.69888888889e-05 2.26 2.71333333333e-05 2.28 2.72777777778e-05 2.3 2.74222222222e-05 2.32 2.75666666667e-05 2.34
+ 2.77111111111e-05 2.36 2.78555555556e-05 2.38 2.8e-05 2.4 2.9e-05 0)
Vd_bl4 d_bl4 0 pwl(
+ 0 0 4e-07 0 5e-07 0.05 2.91e-05 0.05 2.92e-05 0)
Xbl4 g_bl4 d_bl4 0 0 fefet_b16 x0_1=-0.459094099 x0_2=0.208194429 x0_3=0.162299154 x0_4=0.115339993 x0_5=0.0795694638 x0_6=0.0529650001
+ x0_7=0.0333188505 x0_8=0.0190816686 x0_9=0.0091415946 x0_10=0.00264421728 x0_11=-0.00112288642 x0_12=-0.0027809821
+ x0_13=-0.00290573445 x0_14=-0.00206616267 x0_15=-0.000878958064 x0_16=-6.727301e-05
.ic v(xbl4.m)=0.0797335322
Vg_bl5 g_bl5 0 pwl(
+ 0 0 1e-06 0 2e-06 -1.2 2.14444444444e-06 -1.18 2.28888888889e-06 -1.16 2.43333333333e-06 -1.14
+ 2.57777777778e-06 -1.12 2.72222222222e-06 -1.1 2.86666666667e-06 -1.08 3.01111111111e-06 -1.06 3.15555555556e-06 -1.04 3.3e-06 -1.02
+ 3.44444444444e-06 -1 3.58888888889e-06 -0.98 3.73333333333e-06 -0.96 3.87777777778e-06 -0.94 4.02222222222e-06 -0.92 4.16666666667e-06 -0.9
+ 4.31111111111e-06 -0.88 4.45555555556e-06 -0.86 4.6e-06 -0.84 4.74444444444e-06 -0.82 4.88888888889e-06 -0.8 5.03333333333e-06 -0.78
+ 5.17777777778e-06 -0.76 5.32222222222e-06 -0.74 5.46666666667e-06 -0.72 5.61111111111e-06 -0.7 5.75555555556e-06 -0.68 5.9e-06 -0.66
+ 6.04444444444e-06 -0.64 6.18888888889e-06 -0.62 6.33333333333e-06 -0.6 6.47777777778e-06 -0.58 6.62222222222e-06 -0.56 6.76666666667e-06 -0.54
+ 6.91111111111e-06 -0.52 7.05555555556e-06 -0.5 7.2e-06 -0.48 7.34444444444e-06 -0.46 7.48888888889e-06 -0.44 7.63333333333e-06 -0.42
+ 7.77777777778e-06 -0.4 7.92222222222e-06 -0.38 8.06666666667e-06 -0.36 8.21111111111e-06 -0.34 8.35555555556e-06 -0.32 8.5e-06 -0.3
+ 8.64444444444e-06 -0.28 8.78888888889e-06 -0.26 8.93333333333e-06 -0.24 9.07777777778e-06 -0.22 9.22222222222e-06 -0.2 9.36666666667e-06 -0.18
+ 9.51111111111e-06 -0.16 9.65555555556e-06 -0.14 9.8e-06 -0.12 9.94444444444e-06 -0.1 1.00888888889e-05 -0.08 1.02333333333e-05 -0.06
+ 1.03777777778e-05 -0.04 1.05222222222e-05 -0.02 1.06666666667e-05 -2.22045e-16 1.08111111111e-05 0.02 1.09555555556e-05 0.04 1.11e-05 0.06
+ 1.12444444444e-05 0.08 1.13888888889e-05 0.1 1.15333333333e-05 0.12 1.16777777778e-05 0.14 1.18222222222e-05 0.16 1.19666666667e-05 0.18
+ 1.21111111111e-05 0.2 1.22555555556e-05 0.22 1.24e-05 0.24 1.25444444444e-05 0.26 1.26888888889e-05 0.28 1.28333333333e-05 0.3
+ 1.29777777778e-05 0.32 1.31222222222e-05 0.34 1.32666666667e-05 0.36 1.34111111111e-05 0.38 1.35555555556e-05 0.4 1.37e-05 0.42
+ 1.38444444444e-05 0.44 1.39888888889e-05 0.46 1.41333333333e-05 0.48 1.42777777778e-05 0.5 1.44222222222e-05 0.52 1.45666666667e-05 0.54
+ 1.47111111111e-05 0.56 1.48555555556e-05 0.58 1.5e-05 0.6 1.51444444444e-05 0.62 1.52888888889e-05 0.64 1.54333333333e-05 0.66
+ 1.55777777778e-05 0.68 1.57222222222e-05 0.7 1.58666666667e-05 0.72 1.60111111111e-05 0.74 1.61555555556e-05 0.76 1.63e-05 0.78
+ 1.64444444444e-05 0.8 1.65888888889e-05 0.82 1.67333333333e-05 0.84 1.68777777778e-05 0.86 1.70222222222e-05 0.88 1.71666666667e-05 0.9
+ 1.73111111111e-05 0.92 1.74555555556e-05 0.94 1.76e-05 0.96 1.77444444444e-05 0.98 1.78888888889e-05 1 1.80333333333e-05 1.02
+ 1.81777777778e-05 1.04 1.83222222222e-05 1.06 1.84666666667e-05 1.08 1.86111111111e-05 1.1 1.87555555556e-05 1.12 1.89e-05 1.14
+ 1.90444444444e-05 1.16 1.91888888889e-05 1.18 1.93333333333e-05 1.2 1.94777777778e-05 1.22 1.96222222222e-05 1.24 1.97666666667e-05 1.26
+ 1.99111111111e-05 1.28 2.00555555556e-05 1.3 2.02e-05 1.32 2.03444444444e-05 1.34 2.04888888889e-05 1.36 2.06333333333e-05 1.38
+ 2.07777777778e-05 1.4 2.09222222222e-05 1.42 2.10666666667e-05 1.44 2.12111111111e-05 1.46 2.13555555556e-05 1.48 2.15e-05 1.5
+ 2.16444444444e-05 1.52 2.17888888889e-05 1.54 2.19333333333e-05 1.56 2.20777777778e-05 1.58 2.22222222222e-05 1.6 2.23666666667e-05 1.62
+ 2.25111111111e-05 1.64 2.26555555556e-05 1.66 2.28e-05 1.68 2.29444444444e-05 1.7 2.30888888889e-05 1.72 2.32333333333e-05 1.74
+ 2.33777777778e-05 1.76 2.35222222222e-05 1.78 2.36666666667e-05 1.8 2.38111111111e-05 1.82 2.39555555556e-05 1.84 2.41e-05 1.86
+ 2.42444444444e-05 1.88 2.43888888889e-05 1.9 2.45333333333e-05 1.92 2.46777777778e-05 1.94 2.48222222222e-05 1.96 2.49666666667e-05 1.98
+ 2.51111111111e-05 2 2.52555555556e-05 2.02 2.54e-05 2.04 2.55444444444e-05 2.06 2.56888888889e-05 2.08 2.58333333333e-05 2.1
+ 2.59777777778e-05 2.12 2.61222222222e-05 2.14 2.62666666667e-05 2.16 2.64111111111e-05 2.18 2.65555555556e-05 2.2 2.67e-05 2.22
+ 2.68444444444e-05 2.24 2.69888888889e-05 2.26 2.71333333333e-05 2.28 2.72777777778e-05 2.3 2.74222222222e-05 2.32 2.75666666667e-05 2.34
+ 2.77111111111e-05 2.36 2.78555555556e-05 2.38 2.8e-05 2.4 2.9e-05 0)
Vd_bl5 d_bl5 0 pwl(
+ 0 0 4e-07 0 5e-07 0.05 2.91e-05 0.05 2.92e-05 0)
Xbl5 g_bl5 d_bl5 0 0 fefet_b16 x0_1=-0.475920292 x0_2=0.208194429 x0_3=0.162299154 x0_4=0.115339993 x0_5=0.0795694638 x0_6=0.0529650001
+ x0_7=0.0333188505 x0_8=0.0190816686 x0_9=0.0091415946 x0_10=0.00264421728 x0_11=-0.00112288642 x0_12=-0.0027809821
+ x0_13=-0.00290573445 x0_14=-0.00206616267 x0_15=-0.000878958064 x0_16=-6.727301e-05
.ic v(xbl5.m)=0.0734609966
Vg_bh0 g_bh0 0 pwl(
+ 0 0 1e-06 0 2e-06 -1.2 2.14444444444e-06 -1.18 2.28888888889e-06 -1.16 2.43333333333e-06 -1.14
+ 2.57777777778e-06 -1.12 2.72222222222e-06 -1.1 2.86666666667e-06 -1.08 3.01111111111e-06 -1.06 3.15555555556e-06 -1.04 3.3e-06 -1.02
+ 3.44444444444e-06 -1 3.58888888889e-06 -0.98 3.73333333333e-06 -0.96 3.87777777778e-06 -0.94 4.02222222222e-06 -0.92 4.16666666667e-06 -0.9
+ 4.31111111111e-06 -0.88 4.45555555556e-06 -0.86 4.6e-06 -0.84 4.74444444444e-06 -0.82 4.88888888889e-06 -0.8 5.03333333333e-06 -0.78
+ 5.17777777778e-06 -0.76 5.32222222222e-06 -0.74 5.46666666667e-06 -0.72 5.61111111111e-06 -0.7 5.75555555556e-06 -0.68 5.9e-06 -0.66
+ 6.04444444444e-06 -0.64 6.18888888889e-06 -0.62 6.33333333333e-06 -0.6 6.47777777778e-06 -0.58 6.62222222222e-06 -0.56 6.76666666667e-06 -0.54
+ 6.91111111111e-06 -0.52 7.05555555556e-06 -0.5 7.2e-06 -0.48 7.34444444444e-06 -0.46 7.48888888889e-06 -0.44 7.63333333333e-06 -0.42
+ 7.77777777778e-06 -0.4 7.92222222222e-06 -0.38 8.06666666667e-06 -0.36 8.21111111111e-06 -0.34 8.35555555556e-06 -0.32 8.5e-06 -0.3
+ 8.64444444444e-06 -0.28 8.78888888889e-06 -0.26 8.93333333333e-06 -0.24 9.07777777778e-06 -0.22 9.22222222222e-06 -0.2 9.36666666667e-06 -0.18
+ 9.51111111111e-06 -0.16 9.65555555556e-06 -0.14 9.8e-06 -0.12 9.94444444444e-06 -0.1 1.00888888889e-05 -0.08 1.02333333333e-05 -0.06
+ 1.03777777778e-05 -0.04 1.05222222222e-05 -0.02 1.06666666667e-05 -2.22045e-16 1.08111111111e-05 0.02 1.09555555556e-05 0.04 1.11e-05 0.06
+ 1.12444444444e-05 0.08 1.13888888889e-05 0.1 1.15333333333e-05 0.12 1.16777777778e-05 0.14 1.18222222222e-05 0.16 1.19666666667e-05 0.18
+ 1.21111111111e-05 0.2 1.22555555556e-05 0.22 1.24e-05 0.24 1.25444444444e-05 0.26 1.26888888889e-05 0.28 1.28333333333e-05 0.3
+ 1.29777777778e-05 0.32 1.31222222222e-05 0.34 1.32666666667e-05 0.36 1.34111111111e-05 0.38 1.35555555556e-05 0.4 1.37e-05 0.42
+ 1.38444444444e-05 0.44 1.39888888889e-05 0.46 1.41333333333e-05 0.48 1.42777777778e-05 0.5 1.44222222222e-05 0.52 1.45666666667e-05 0.54
+ 1.47111111111e-05 0.56 1.48555555556e-05 0.58 1.5e-05 0.6 1.51444444444e-05 0.62 1.52888888889e-05 0.64 1.54333333333e-05 0.66
+ 1.55777777778e-05 0.68 1.57222222222e-05 0.7 1.58666666667e-05 0.72 1.60111111111e-05 0.74 1.61555555556e-05 0.76 1.63e-05 0.78
+ 1.64444444444e-05 0.8 1.65888888889e-05 0.82 1.67333333333e-05 0.84 1.68777777778e-05 0.86 1.70222222222e-05 0.88 1.71666666667e-05 0.9
+ 1.73111111111e-05 0.92 1.74555555556e-05 0.94 1.76e-05 0.96 1.77444444444e-05 0.98 1.78888888889e-05 1 1.80333333333e-05 1.02
+ 1.81777777778e-05 1.04 1.83222222222e-05 1.06 1.84666666667e-05 1.08 1.86111111111e-05 1.1 1.87555555556e-05 1.12 1.89e-05 1.14
+ 1.90444444444e-05 1.16 1.91888888889e-05 1.18 1.93333333333e-05 1.2 1.94777777778e-05 1.22 1.96222222222e-05 1.24 1.97666666667e-05 1.26
+ 1.99111111111e-05 1.28 2.00555555556e-05 1.3 2.02e-05 1.32 2.03444444444e-05 1.34 2.04888888889e-05 1.36 2.06333333333e-05 1.38
+ 2.07777777778e-05 1.4 2.09222222222e-05 1.42 2.10666666667e-05 1.44 2.12111111111e-05 1.46 2.13555555556e-05 1.48 2.15e-05 1.5
+ 2.16444444444e-05 1.52 2.17888888889e-05 1.54 2.19333333333e-05 1.56 2.20777777778e-05 1.58 2.22222222222e-05 1.6 2.23666666667e-05 1.62
+ 2.25111111111e-05 1.64 2.26555555556e-05 1.66 2.28e-05 1.68 2.29444444444e-05 1.7 2.30888888889e-05 1.72 2.32333333333e-05 1.74
+ 2.33777777778e-05 1.76 2.35222222222e-05 1.78 2.36666666667e-05 1.8 2.38111111111e-05 1.82 2.39555555556e-05 1.84 2.41e-05 1.86
+ 2.42444444444e-05 1.88 2.43888888889e-05 1.9 2.45333333333e-05 1.92 2.46777777778e-05 1.94 2.48222222222e-05 1.96 2.49666666667e-05 1.98
+ 2.51111111111e-05 2 2.52555555556e-05 2.02 2.54e-05 2.04 2.55444444444e-05 2.06 2.56888888889e-05 2.08 2.58333333333e-05 2.1
+ 2.59777777778e-05 2.12 2.61222222222e-05 2.14 2.62666666667e-05 2.16 2.64111111111e-05 2.18 2.65555555556e-05 2.2 2.67e-05 2.22
+ 2.68444444444e-05 2.24 2.69888888889e-05 2.26 2.71333333333e-05 2.28 2.72777777778e-05 2.3 2.74222222222e-05 2.32 2.75666666667e-05 2.34
+ 2.77111111111e-05 2.36 2.78555555556e-05 2.38 2.8e-05 2.4 2.9e-05 0)
Vd_bh0 d_bh0 0 pwl(
+ 0 0 4e-07 0 5e-07 0.05 2.91e-05 0.05 2.92e-05 0)
Xbh0 g_bh0 d_bh0 0 0 fefet_b16 x0_1=0.161430918 x0_2=-0.271437025 x0_3=-0.22265841 x0_4=-0.179678028 x0_5=-0.146825874 x0_6=-0.12104344
+ x0_7=-0.0998549702 x0_8=-0.081684736 x0_9=-0.0656050025 x0_10=-0.0511330719 x0_11=-0.0380691753 x0_12=-0.0264272707
+ x0_13=-0.0163825537 x0_14=-0.00828112591 x0_15=-0.00265407502 x0_16=-0.000142689132
.ic v(xbh0.m)=-0.432722171
Vg_bh1 g_bh1 0 pwl(
+ 0 0 1e-06 0 2e-06 -1.2 2.14444444444e-06 -1.18 2.28888888889e-06 -1.16 2.43333333333e-06 -1.14
+ 2.57777777778e-06 -1.12 2.72222222222e-06 -1.1 2.86666666667e-06 -1.08 3.01111111111e-06 -1.06 3.15555555556e-06 -1.04 3.3e-06 -1.02
+ 3.44444444444e-06 -1 3.58888888889e-06 -0.98 3.73333333333e-06 -0.96 3.87777777778e-06 -0.94 4.02222222222e-06 -0.92 4.16666666667e-06 -0.9
+ 4.31111111111e-06 -0.88 4.45555555556e-06 -0.86 4.6e-06 -0.84 4.74444444444e-06 -0.82 4.88888888889e-06 -0.8 5.03333333333e-06 -0.78
+ 5.17777777778e-06 -0.76 5.32222222222e-06 -0.74 5.46666666667e-06 -0.72 5.61111111111e-06 -0.7 5.75555555556e-06 -0.68 5.9e-06 -0.66
+ 6.04444444444e-06 -0.64 6.18888888889e-06 -0.62 6.33333333333e-06 -0.6 6.47777777778e-06 -0.58 6.62222222222e-06 -0.56 6.76666666667e-06 -0.54
+ 6.91111111111e-06 -0.52 7.05555555556e-06 -0.5 7.2e-06 -0.48 7.34444444444e-06 -0.46 7.48888888889e-06 -0.44 7.63333333333e-06 -0.42
+ 7.77777777778e-06 -0.4 7.92222222222e-06 -0.38 8.06666666667e-06 -0.36 8.21111111111e-06 -0.34 8.35555555556e-06 -0.32 8.5e-06 -0.3
+ 8.64444444444e-06 -0.28 8.78888888889e-06 -0.26 8.93333333333e-06 -0.24 9.07777777778e-06 -0.22 9.22222222222e-06 -0.2 9.36666666667e-06 -0.18
+ 9.51111111111e-06 -0.16 9.65555555556e-06 -0.14 9.8e-06 -0.12 9.94444444444e-06 -0.1 1.00888888889e-05 -0.08 1.02333333333e-05 -0.06
+ 1.03777777778e-05 -0.04 1.05222222222e-05 -0.02 1.06666666667e-05 -2.22045e-16 1.08111111111e-05 0.02 1.09555555556e-05 0.04 1.11e-05 0.06
+ 1.12444444444e-05 0.08 1.13888888889e-05 0.1 1.15333333333e-05 0.12 1.16777777778e-05 0.14 1.18222222222e-05 0.16 1.19666666667e-05 0.18
+ 1.21111111111e-05 0.2 1.22555555556e-05 0.22 1.24e-05 0.24 1.25444444444e-05 0.26 1.26888888889e-05 0.28 1.28333333333e-05 0.3
+ 1.29777777778e-05 0.32 1.31222222222e-05 0.34 1.32666666667e-05 0.36 1.34111111111e-05 0.38 1.35555555556e-05 0.4 1.37e-05 0.42
+ 1.38444444444e-05 0.44 1.39888888889e-05 0.46 1.41333333333e-05 0.48 1.42777777778e-05 0.5 1.44222222222e-05 0.52 1.45666666667e-05 0.54
+ 1.47111111111e-05 0.56 1.48555555556e-05 0.58 1.5e-05 0.6 1.51444444444e-05 0.62 1.52888888889e-05 0.64 1.54333333333e-05 0.66
+ 1.55777777778e-05 0.68 1.57222222222e-05 0.7 1.58666666667e-05 0.72 1.60111111111e-05 0.74 1.61555555556e-05 0.76 1.63e-05 0.78
+ 1.64444444444e-05 0.8 1.65888888889e-05 0.82 1.67333333333e-05 0.84 1.68777777778e-05 0.86 1.70222222222e-05 0.88 1.71666666667e-05 0.9
+ 1.73111111111e-05 0.92 1.74555555556e-05 0.94 1.76e-05 0.96 1.77444444444e-05 0.98 1.78888888889e-05 1 1.80333333333e-05 1.02
+ 1.81777777778e-05 1.04 1.83222222222e-05 1.06 1.84666666667e-05 1.08 1.86111111111e-05 1.1 1.87555555556e-05 1.12 1.89e-05 1.14
+ 1.90444444444e-05 1.16 1.91888888889e-05 1.18 1.93333333333e-05 1.2 1.94777777778e-05 1.22 1.96222222222e-05 1.24 1.97666666667e-05 1.26
+ 1.99111111111e-05 1.28 2.00555555556e-05 1.3 2.02e-05 1.32 2.03444444444e-05 1.34 2.04888888889e-05 1.36 2.06333333333e-05 1.38
+ 2.07777777778e-05 1.4 2.09222222222e-05 1.42 2.10666666667e-05 1.44 2.12111111111e-05 1.46 2.13555555556e-05 1.48 2.15e-05 1.5
+ 2.16444444444e-05 1.52 2.17888888889e-05 1.54 2.19333333333e-05 1.56 2.20777777778e-05 1.58 2.22222222222e-05 1.6 2.23666666667e-05 1.62
+ 2.25111111111e-05 1.64 2.26555555556e-05 1.66 2.28e-05 1.68 2.29444444444e-05 1.7 2.30888888889e-05 1.72 2.32333333333e-05 1.74
+ 2.33777777778e-05 1.76 2.35222222222e-05 1.78 2.36666666667e-05 1.8 2.38111111111e-05 1.82 2.39555555556e-05 1.84 2.41e-05 1.86
+ 2.42444444444e-05 1.88 2.43888888889e-05 1.9 2.45333333333e-05 1.92 2.46777777778e-05 1.94 2.48222222222e-05 1.96 2.49666666667e-05 1.98
+ 2.51111111111e-05 2 2.52555555556e-05 2.02 2.54e-05 2.04 2.55444444444e-05 2.06 2.56888888889e-05 2.08 2.58333333333e-05 2.1
+ 2.59777777778e-05 2.12 2.61222222222e-05 2.14 2.62666666667e-05 2.16 2.64111111111e-05 2.18 2.65555555556e-05 2.2 2.67e-05 2.22
+ 2.68444444444e-05 2.24 2.69888888889e-05 2.26 2.71333333333e-05 2.28 2.72777777778e-05 2.3 2.74222222222e-05 2.32 2.75666666667e-05 2.34
+ 2.77111111111e-05 2.36 2.78555555556e-05 2.38 2.8e-05 2.4 2.9e-05 0)
Vd_bh1 d_bh1 0 pwl(
+ 0 0 4e-07 0 5e-07 0.05 2.91e-05 0.05 2.92e-05 0)
Xbh1 g_bh1 d_bh1 0 0 fefet_b16 x0_1=0.214912072 x0_2=-0.271436965 x0_3=-0.22265841 x0_4=-0.179678028 x0_5=-0.146825874 x0_6=-0.12104344
+ x0_7=-0.0998549702 x0_8=-0.081684736 x0_9=-0.0656050025 x0_10=-0.0511330719 x0_11=-0.0380691753 x0_12=-0.0264272707
+ x0_13=-0.0163825537 x0_14=-0.00828112591 x0_15=-0.00265407502 x0_16=-0.000142689132
.ic v(xbh1.m)=-0.413214883
Vg_bh2 g_bh2 0 pwl(
+ 0 0 1e-06 0 2e-06 -1.2 2.14444444444e-06 -1.18 2.28888888889e-06 -1.16 2.43333333333e-06 -1.14
+ 2.57777777778e-06 -1.12 2.72222222222e-06 -1.1 2.86666666667e-06 -1.08 3.01111111111e-06 -1.06 3.15555555556e-06 -1.04 3.3e-06 -1.02
+ 3.44444444444e-06 -1 3.58888888889e-06 -0.98 3.73333333333e-06 -0.96 3.87777777778e-06 -0.94 4.02222222222e-06 -0.92 4.16666666667e-06 -0.9
+ 4.31111111111e-06 -0.88 4.45555555556e-06 -0.86 4.6e-06 -0.84 4.74444444444e-06 -0.82 4.88888888889e-06 -0.8 5.03333333333e-06 -0.78
+ 5.17777777778e-06 -0.76 5.32222222222e-06 -0.74 5.46666666667e-06 -0.72 5.61111111111e-06 -0.7 5.75555555556e-06 -0.68 5.9e-06 -0.66
+ 6.04444444444e-06 -0.64 6.18888888889e-06 -0.62 6.33333333333e-06 -0.6 6.47777777778e-06 -0.58 6.62222222222e-06 -0.56 6.76666666667e-06 -0.54
+ 6.91111111111e-06 -0.52 7.05555555556e-06 -0.5 7.2e-06 -0.48 7.34444444444e-06 -0.46 7.48888888889e-06 -0.44 7.63333333333e-06 -0.42
+ 7.77777777778e-06 -0.4 7.92222222222e-06 -0.38 8.06666666667e-06 -0.36 8.21111111111e-06 -0.34 8.35555555556e-06 -0.32 8.5e-06 -0.3
+ 8.64444444444e-06 -0.28 8.78888888889e-06 -0.26 8.93333333333e-06 -0.24 9.07777777778e-06 -0.22 9.22222222222e-06 -0.2 9.36666666667e-06 -0.18
+ 9.51111111111e-06 -0.16 9.65555555556e-06 -0.14 9.8e-06 -0.12 9.94444444444e-06 -0.1 1.00888888889e-05 -0.08 1.02333333333e-05 -0.06
+ 1.03777777778e-05 -0.04 1.05222222222e-05 -0.02 1.06666666667e-05 -2.22045e-16 1.08111111111e-05 0.02 1.09555555556e-05 0.04 1.11e-05 0.06
+ 1.12444444444e-05 0.08 1.13888888889e-05 0.1 1.15333333333e-05 0.12 1.16777777778e-05 0.14 1.18222222222e-05 0.16 1.19666666667e-05 0.18
+ 1.21111111111e-05 0.2 1.22555555556e-05 0.22 1.24e-05 0.24 1.25444444444e-05 0.26 1.26888888889e-05 0.28 1.28333333333e-05 0.3
+ 1.29777777778e-05 0.32 1.31222222222e-05 0.34 1.32666666667e-05 0.36 1.34111111111e-05 0.38 1.35555555556e-05 0.4 1.37e-05 0.42
+ 1.38444444444e-05 0.44 1.39888888889e-05 0.46 1.41333333333e-05 0.48 1.42777777778e-05 0.5 1.44222222222e-05 0.52 1.45666666667e-05 0.54
+ 1.47111111111e-05 0.56 1.48555555556e-05 0.58 1.5e-05 0.6 1.51444444444e-05 0.62 1.52888888889e-05 0.64 1.54333333333e-05 0.66
+ 1.55777777778e-05 0.68 1.57222222222e-05 0.7 1.58666666667e-05 0.72 1.60111111111e-05 0.74 1.61555555556e-05 0.76 1.63e-05 0.78
+ 1.64444444444e-05 0.8 1.65888888889e-05 0.82 1.67333333333e-05 0.84 1.68777777778e-05 0.86 1.70222222222e-05 0.88 1.71666666667e-05 0.9
+ 1.73111111111e-05 0.92 1.74555555556e-05 0.94 1.76e-05 0.96 1.77444444444e-05 0.98 1.78888888889e-05 1 1.80333333333e-05 1.02
+ 1.81777777778e-05 1.04 1.83222222222e-05 1.06 1.84666666667e-05 1.08 1.86111111111e-05 1.1 1.87555555556e-05 1.12 1.89e-05 1.14
+ 1.90444444444e-05 1.16 1.91888888889e-05 1.18 1.93333333333e-05 1.2 1.94777777778e-05 1.22 1.96222222222e-05 1.24 1.97666666667e-05 1.26
+ 1.99111111111e-05 1.28 2.00555555556e-05 1.3 2.02e-05 1.32 2.03444444444e-05 1.34 2.04888888889e-05 1.36 2.06333333333e-05 1.38
+ 2.07777777778e-05 1.4 2.09222222222e-05 1.42 2.10666666667e-05 1.44 2.12111111111e-05 1.46 2.13555555556e-05 1.48 2.15e-05 1.5
+ 2.16444444444e-05 1.52 2.17888888889e-05 1.54 2.19333333333e-05 1.56 2.20777777778e-05 1.58 2.22222222222e-05 1.6 2.23666666667e-05 1.62
+ 2.25111111111e-05 1.64 2.26555555556e-05 1.66 2.28e-05 1.68 2.29444444444e-05 1.7 2.30888888889e-05 1.72 2.32333333333e-05 1.74
+ 2.33777777778e-05 1.76 2.35222222222e-05 1.78 2.36666666667e-05 1.8 2.38111111111e-05 1.82 2.39555555556e-05 1.84 2.41e-05 1.86
+ 2.42444444444e-05 1.88 2.43888888889e-05 1.9 2.45333333333e-05 1.92 2.46777777778e-05 1.94 2.48222222222e-05 1.96 2.49666666667e-05 1.98
+ 2.51111111111e-05 2 2.52555555556e-05 2.02 2.54e-05 2.04 2.55444444444e-05 2.06 2.56888888889e-05 2.08 2.58333333333e-05 2.1
+ 2.59777777778e-05 2.12 2.61222222222e-05 2.14 2.62666666667e-05 2.16 2.64111111111e-05 2.18 2.65555555556e-05 2.2 2.67e-05 2.22
+ 2.68444444444e-05 2.24 2.69888888889e-05 2.26 2.71333333333e-05 2.28 2.72777777778e-05 2.3 2.74222222222e-05 2.32 2.75666666667e-05 2.34
+ 2.77111111111e-05 2.36 2.78555555556e-05 2.38 2.8e-05 2.4 2.9e-05 0)
Vd_bh2 d_bh2 0 pwl(
+ 0 0 4e-07 0 5e-07 0.05 2.91e-05 0.05 2.92e-05 0)
Xbh2 g_bh2 d_bh2 0 0 fefet_b16 x0_1=0.23963911 x0_2=-0.271436963 x0_3=-0.22265841 x0_4=-0.179678028 x0_5=-0.146825874 x0_6=-0.12104344
+ x0_7=-0.0998549702 x0_8=-0.081684736 x0_9=-0.0656050025 x0_10=-0.0511330719 x0_11=-0.0380691753 x0_12=-0.0264272707
+ x0_13=-0.0163825537 x0_14=-0.00828112591 x0_15=-0.00265407502 x0_16=-0.000142689132
.ic v(xbh2.m)=-0.404183316
Vg_bh3 g_bh3 0 pwl(
+ 0 0 1e-06 0 2e-06 -1.2 2.14444444444e-06 -1.18 2.28888888889e-06 -1.16 2.43333333333e-06 -1.14
+ 2.57777777778e-06 -1.12 2.72222222222e-06 -1.1 2.86666666667e-06 -1.08 3.01111111111e-06 -1.06 3.15555555556e-06 -1.04 3.3e-06 -1.02
+ 3.44444444444e-06 -1 3.58888888889e-06 -0.98 3.73333333333e-06 -0.96 3.87777777778e-06 -0.94 4.02222222222e-06 -0.92 4.16666666667e-06 -0.9
+ 4.31111111111e-06 -0.88 4.45555555556e-06 -0.86 4.6e-06 -0.84 4.74444444444e-06 -0.82 4.88888888889e-06 -0.8 5.03333333333e-06 -0.78
+ 5.17777777778e-06 -0.76 5.32222222222e-06 -0.74 5.46666666667e-06 -0.72 5.61111111111e-06 -0.7 5.75555555556e-06 -0.68 5.9e-06 -0.66
+ 6.04444444444e-06 -0.64 6.18888888889e-06 -0.62 6.33333333333e-06 -0.6 6.47777777778e-06 -0.58 6.62222222222e-06 -0.56 6.76666666667e-06 -0.54
+ 6.91111111111e-06 -0.52 7.05555555556e-06 -0.5 7.2e-06 -0.48 7.34444444444e-06 -0.46 7.48888888889e-06 -0.44 7.63333333333e-06 -0.42
+ 7.77777777778e-06 -0.4 7.92222222222e-06 -0.38 8.06666666667e-06 -0.36 8.21111111111e-06 -0.34 8.35555555556e-06 -0.32 8.5e-06 -0.3
+ 8.64444444444e-06 -0.28 8.78888888889e-06 -0.26 8.93333333333e-06 -0.24 9.07777777778e-06 -0.22 9.22222222222e-06 -0.2 9.36666666667e-06 -0.18
+ 9.51111111111e-06 -0.16 9.65555555556e-06 -0.14 9.8e-06 -0.12 9.94444444444e-06 -0.1 1.00888888889e-05 -0.08 1.02333333333e-05 -0.06
+ 1.03777777778e-05 -0.04 1.05222222222e-05 -0.02 1.06666666667e-05 -2.22045e-16 1.08111111111e-05 0.02 1.09555555556e-05 0.04 1.11e-05 0.06
+ 1.12444444444e-05 0.08 1.13888888889e-05 0.1 1.15333333333e-05 0.12 1.16777777778e-05 0.14 1.18222222222e-05 0.16 1.19666666667e-05 0.18
+ 1.21111111111e-05 0.2 1.22555555556e-05 0.22 1.24e-05 0.24 1.25444444444e-05 0.26 1.26888888889e-05 0.28 1.28333333333e-05 0.3
+ 1.29777777778e-05 0.32 1.31222222222e-05 0.34 1.32666666667e-05 0.36 1.34111111111e-05 0.38 1.35555555556e-05 0.4 1.37e-05 0.42
+ 1.38444444444e-05 0.44 1.39888888889e-05 0.46 1.41333333333e-05 0.48 1.42777777778e-05 0.5 1.44222222222e-05 0.52 1.45666666667e-05 0.54
+ 1.47111111111e-05 0.56 1.48555555556e-05 0.58 1.5e-05 0.6 1.51444444444e-05 0.62 1.52888888889e-05 0.64 1.54333333333e-05 0.66
+ 1.55777777778e-05 0.68 1.57222222222e-05 0.7 1.58666666667e-05 0.72 1.60111111111e-05 0.74 1.61555555556e-05 0.76 1.63e-05 0.78
+ 1.64444444444e-05 0.8 1.65888888889e-05 0.82 1.67333333333e-05 0.84 1.68777777778e-05 0.86 1.70222222222e-05 0.88 1.71666666667e-05 0.9
+ 1.73111111111e-05 0.92 1.74555555556e-05 0.94 1.76e-05 0.96 1.77444444444e-05 0.98 1.78888888889e-05 1 1.80333333333e-05 1.02
+ 1.81777777778e-05 1.04 1.83222222222e-05 1.06 1.84666666667e-05 1.08 1.86111111111e-05 1.1 1.87555555556e-05 1.12 1.89e-05 1.14
+ 1.90444444444e-05 1.16 1.91888888889e-05 1.18 1.93333333333e-05 1.2 1.94777777778e-05 1.22 1.96222222222e-05 1.24 1.97666666667e-05 1.26
+ 1.99111111111e-05 1.28 2.00555555556e-05 1.3 2.02e-05 1.32 2.03444444444e-05 1.34 2.04888888889e-05 1.36 2.06333333333e-05 1.38
+ 2.07777777778e-05 1.4 2.09222222222e-05 1.42 2.10666666667e-05 1.44 2.12111111111e-05 1.46 2.13555555556e-05 1.48 2.15e-05 1.5
+ 2.16444444444e-05 1.52 2.17888888889e-05 1.54 2.19333333333e-05 1.56 2.20777777778e-05 1.58 2.22222222222e-05 1.6 2.23666666667e-05 1.62
+ 2.25111111111e-05 1.64 2.26555555556e-05 1.66 2.28e-05 1.68 2.29444444444e-05 1.7 2.30888888889e-05 1.72 2.32333333333e-05 1.74
+ 2.33777777778e-05 1.76 2.35222222222e-05 1.78 2.36666666667e-05 1.8 2.38111111111e-05 1.82 2.39555555556e-05 1.84 2.41e-05 1.86
+ 2.42444444444e-05 1.88 2.43888888889e-05 1.9 2.45333333333e-05 1.92 2.46777777778e-05 1.94 2.48222222222e-05 1.96 2.49666666667e-05 1.98
+ 2.51111111111e-05 2 2.52555555556e-05 2.02 2.54e-05 2.04 2.55444444444e-05 2.06 2.56888888889e-05 2.08 2.58333333333e-05 2.1
+ 2.59777777778e-05 2.12 2.61222222222e-05 2.14 2.62666666667e-05 2.16 2.64111111111e-05 2.18 2.65555555556e-05 2.2 2.67e-05 2.22
+ 2.68444444444e-05 2.24 2.69888888889e-05 2.26 2.71333333333e-05 2.28 2.72777777778e-05 2.3 2.74222222222e-05 2.32 2.75666666667e-05 2.34
+ 2.77111111111e-05 2.36 2.78555555556e-05 2.38 2.8e-05 2.4 2.9e-05 0)
Vd_bh3 d_bh3 0 pwl(
+ 0 0 4e-07 0 5e-07 0.05 2.91e-05 0.05 2.92e-05 0)
Xbh3 g_bh3 d_bh3 0 0 fefet_b16 x0_1=0.261346206 x0_2=-0.271436962 x0_3=-0.22265841 x0_4=-0.179678028 x0_5=-0.146825874 x0_6=-0.12104344
+ x0_7=-0.0998549702 x0_8=-0.081684736 x0_9=-0.0656050025 x0_10=-0.0511330719 x0_11=-0.0380691753 x0_12=-0.0264272707
+ x0_13=-0.0163825537 x0_14=-0.00828112591 x0_15=-0.00265407502 x0_16=-0.000142689132
.ic v(xbh3.m)=-0.396248619
Vg_bh4 g_bh4 0 pwl(
+ 0 0 1e-06 0 2e-06 -1.2 2.14444444444e-06 -1.18 2.28888888889e-06 -1.16 2.43333333333e-06 -1.14
+ 2.57777777778e-06 -1.12 2.72222222222e-06 -1.1 2.86666666667e-06 -1.08 3.01111111111e-06 -1.06 3.15555555556e-06 -1.04 3.3e-06 -1.02
+ 3.44444444444e-06 -1 3.58888888889e-06 -0.98 3.73333333333e-06 -0.96 3.87777777778e-06 -0.94 4.02222222222e-06 -0.92 4.16666666667e-06 -0.9
+ 4.31111111111e-06 -0.88 4.45555555556e-06 -0.86 4.6e-06 -0.84 4.74444444444e-06 -0.82 4.88888888889e-06 -0.8 5.03333333333e-06 -0.78
+ 5.17777777778e-06 -0.76 5.32222222222e-06 -0.74 5.46666666667e-06 -0.72 5.61111111111e-06 -0.7 5.75555555556e-06 -0.68 5.9e-06 -0.66
+ 6.04444444444e-06 -0.64 6.18888888889e-06 -0.62 6.33333333333e-06 -0.6 6.47777777778e-06 -0.58 6.62222222222e-06 -0.56 6.76666666667e-06 -0.54
+ 6.91111111111e-06 -0.52 7.05555555556e-06 -0.5 7.2e-06 -0.48 7.34444444444e-06 -0.46 7.48888888889e-06 -0.44 7.63333333333e-06 -0.42
+ 7.77777777778e-06 -0.4 7.92222222222e-06 -0.38 8.06666666667e-06 -0.36 8.21111111111e-06 -0.34 8.35555555556e-06 -0.32 8.5e-06 -0.3
+ 8.64444444444e-06 -0.28 8.78888888889e-06 -0.26 8.93333333333e-06 -0.24 9.07777777778e-06 -0.22 9.22222222222e-06 -0.2 9.36666666667e-06 -0.18
+ 9.51111111111e-06 -0.16 9.65555555556e-06 -0.14 9.8e-06 -0.12 9.94444444444e-06 -0.1 1.00888888889e-05 -0.08 1.02333333333e-05 -0.06
+ 1.03777777778e-05 -0.04 1.05222222222e-05 -0.02 1.06666666667e-05 -2.22045e-16 1.08111111111e-05 0.02 1.09555555556e-05 0.04 1.11e-05 0.06
+ 1.12444444444e-05 0.08 1.13888888889e-05 0.1 1.15333333333e-05 0.12 1.16777777778e-05 0.14 1.18222222222e-05 0.16 1.19666666667e-05 0.18
+ 1.21111111111e-05 0.2 1.22555555556e-05 0.22 1.24e-05 0.24 1.25444444444e-05 0.26 1.26888888889e-05 0.28 1.28333333333e-05 0.3
+ 1.29777777778e-05 0.32 1.31222222222e-05 0.34 1.32666666667e-05 0.36 1.34111111111e-05 0.38 1.35555555556e-05 0.4 1.37e-05 0.42
+ 1.38444444444e-05 0.44 1.39888888889e-05 0.46 1.41333333333e-05 0.48 1.42777777778e-05 0.5 1.44222222222e-05 0.52 1.45666666667e-05 0.54
+ 1.47111111111e-05 0.56 1.48555555556e-05 0.58 1.5e-05 0.6 1.51444444444e-05 0.62 1.52888888889e-05 0.64 1.54333333333e-05 0.66
+ 1.55777777778e-05 0.68 1.57222222222e-05 0.7 1.58666666667e-05 0.72 1.60111111111e-05 0.74 1.61555555556e-05 0.76 1.63e-05 0.78
+ 1.64444444444e-05 0.8 1.65888888889e-05 0.82 1.67333333333e-05 0.84 1.68777777778e-05 0.86 1.70222222222e-05 0.88 1.71666666667e-05 0.9
+ 1.73111111111e-05 0.92 1.74555555556e-05 0.94 1.76e-05 0.96 1.77444444444e-05 0.98 1.78888888889e-05 1 1.80333333333e-05 1.02
+ 1.81777777778e-05 1.04 1.83222222222e-05 1.06 1.84666666667e-05 1.08 1.86111111111e-05 1.1 1.87555555556e-05 1.12 1.89e-05 1.14
+ 1.90444444444e-05 1.16 1.91888888889e-05 1.18 1.93333333333e-05 1.2 1.94777777778e-05 1.22 1.96222222222e-05 1.24 1.97666666667e-05 1.26
+ 1.99111111111e-05 1.28 2.00555555556e-05 1.3 2.02e-05 1.32 2.03444444444e-05 1.34 2.04888888889e-05 1.36 2.06333333333e-05 1.38
+ 2.07777777778e-05 1.4 2.09222222222e-05 1.42 2.10666666667e-05 1.44 2.12111111111e-05 1.46 2.13555555556e-05 1.48 2.15e-05 1.5
+ 2.16444444444e-05 1.52 2.17888888889e-05 1.54 2.19333333333e-05 1.56 2.20777777778e-05 1.58 2.22222222222e-05 1.6 2.23666666667e-05 1.62
+ 2.25111111111e-05 1.64 2.26555555556e-05 1.66 2.28e-05 1.68 2.29444444444e-05 1.7 2.30888888889e-05 1.72 2.32333333333e-05 1.74
+ 2.33777777778e-05 1.76 2.35222222222e-05 1.78 2.36666666667e-05 1.8 2.38111111111e-05 1.82 2.39555555556e-05 1.84 2.41e-05 1.86
+ 2.42444444444e-05 1.88 2.43888888889e-05 1.9 2.45333333333e-05 1.92 2.46777777778e-05 1.94 2.48222222222e-05 1.96 2.49666666667e-05 1.98
+ 2.51111111111e-05 2 2.52555555556e-05 2.02 2.54e-05 2.04 2.55444444444e-05 2.06 2.56888888889e-05 2.08 2.58333333333e-05 2.1
+ 2.59777777778e-05 2.12 2.61222222222e-05 2.14 2.62666666667e-05 2.16 2.64111111111e-05 2.18 2.65555555556e-05 2.2 2.67e-05 2.22
+ 2.68444444444e-05 2.24 2.69888888889e-05 2.26 2.71333333333e-05 2.28 2.72777777778e-05 2.3 2.74222222222e-05 2.32 2.75666666667e-05 2.34
+ 2.77111111111e-05 2.36 2.78555555556e-05 2.38 2.8e-05 2.4 2.9e-05 0)
Vd_bh4 d_bh4 0 pwl(
+ 0 0 4e-07 0 5e-07 0.05 2.91e-05 0.05 2.92e-05 0)
Xbh4 g_bh4 d_bh4 0 0 fefet_b16 x0_1=0.280484805 x0_2=-0.271436962 x0_3=-0.22265841 x0_4=-0.179678028 x0_5=-0.146825874 x0_6=-0.12104344
+ x0_7=-0.0998549702 x0_8=-0.081684736 x0_9=-0.0656050025 x0_10=-0.0511330719 x0_11=-0.0380691753 x0_12=-0.0264272707
+ x0_13=-0.0163825537 x0_14=-0.00828112591 x0_15=-0.00265407502 x0_16=-0.000142689132
.ic v(xbh4.m)=-0.389248067
Vg_bh5 g_bh5 0 pwl(
+ 0 0 1e-06 0 2e-06 -1.2 2.14444444444e-06 -1.18 2.28888888889e-06 -1.16 2.43333333333e-06 -1.14
+ 2.57777777778e-06 -1.12 2.72222222222e-06 -1.1 2.86666666667e-06 -1.08 3.01111111111e-06 -1.06 3.15555555556e-06 -1.04 3.3e-06 -1.02
+ 3.44444444444e-06 -1 3.58888888889e-06 -0.98 3.73333333333e-06 -0.96 3.87777777778e-06 -0.94 4.02222222222e-06 -0.92 4.16666666667e-06 -0.9
+ 4.31111111111e-06 -0.88 4.45555555556e-06 -0.86 4.6e-06 -0.84 4.74444444444e-06 -0.82 4.88888888889e-06 -0.8 5.03333333333e-06 -0.78
+ 5.17777777778e-06 -0.76 5.32222222222e-06 -0.74 5.46666666667e-06 -0.72 5.61111111111e-06 -0.7 5.75555555556e-06 -0.68 5.9e-06 -0.66
+ 6.04444444444e-06 -0.64 6.18888888889e-06 -0.62 6.33333333333e-06 -0.6 6.47777777778e-06 -0.58 6.62222222222e-06 -0.56 6.76666666667e-06 -0.54
+ 6.91111111111e-06 -0.52 7.05555555556e-06 -0.5 7.2e-06 -0.48 7.34444444444e-06 -0.46 7.48888888889e-06 -0.44 7.63333333333e-06 -0.42
+ 7.77777777778e-06 -0.4 7.92222222222e-06 -0.38 8.06666666667e-06 -0.36 8.21111111111e-06 -0.34 8.35555555556e-06 -0.32 8.5e-06 -0.3
+ 8.64444444444e-06 -0.28 8.78888888889e-06 -0.26 8.93333333333e-06 -0.24 9.07777777778e-06 -0.22 9.22222222222e-06 -0.2 9.36666666667e-06 -0.18
+ 9.51111111111e-06 -0.16 9.65555555556e-06 -0.14 9.8e-06 -0.12 9.94444444444e-06 -0.1 1.00888888889e-05 -0.08 1.02333333333e-05 -0.06
+ 1.03777777778e-05 -0.04 1.05222222222e-05 -0.02 1.06666666667e-05 -2.22045e-16 1.08111111111e-05 0.02 1.09555555556e-05 0.04 1.11e-05 0.06
+ 1.12444444444e-05 0.08 1.13888888889e-05 0.1 1.15333333333e-05 0.12 1.16777777778e-05 0.14 1.18222222222e-05 0.16 1.19666666667e-05 0.18
+ 1.21111111111e-05 0.2 1.22555555556e-05 0.22 1.24e-05 0.24 1.25444444444e-05 0.26 1.26888888889e-05 0.28 1.28333333333e-05 0.3
+ 1.29777777778e-05 0.32 1.31222222222e-05 0.34 1.32666666667e-05 0.36 1.34111111111e-05 0.38 1.35555555556e-05 0.4 1.37e-05 0.42
+ 1.38444444444e-05 0.44 1.39888888889e-05 0.46 1.41333333333e-05 0.48 1.42777777778e-05 0.5 1.44222222222e-05 0.52 1.45666666667e-05 0.54
+ 1.47111111111e-05 0.56 1.48555555556e-05 0.58 1.5e-05 0.6 1.51444444444e-05 0.62 1.52888888889e-05 0.64 1.54333333333e-05 0.66
+ 1.55777777778e-05 0.68 1.57222222222e-05 0.7 1.58666666667e-05 0.72 1.60111111111e-05 0.74 1.61555555556e-05 0.76 1.63e-05 0.78
+ 1.64444444444e-05 0.8 1.65888888889e-05 0.82 1.67333333333e-05 0.84 1.68777777778e-05 0.86 1.70222222222e-05 0.88 1.71666666667e-05 0.9
+ 1.73111111111e-05 0.92 1.74555555556e-05 0.94 1.76e-05 0.96 1.77444444444e-05 0.98 1.78888888889e-05 1 1.80333333333e-05 1.02
+ 1.81777777778e-05 1.04 1.83222222222e-05 1.06 1.84666666667e-05 1.08 1.86111111111e-05 1.1 1.87555555556e-05 1.12 1.89e-05 1.14
+ 1.90444444444e-05 1.16 1.91888888889e-05 1.18 1.93333333333e-05 1.2 1.94777777778e-05 1.22 1.96222222222e-05 1.24 1.97666666667e-05 1.26
+ 1.99111111111e-05 1.28 2.00555555556e-05 1.3 2.02e-05 1.32 2.03444444444e-05 1.34 2.04888888889e-05 1.36 2.06333333333e-05 1.38
+ 2.07777777778e-05 1.4 2.09222222222e-05 1.42 2.10666666667e-05 1.44 2.12111111111e-05 1.46 2.13555555556e-05 1.48 2.15e-05 1.5
+ 2.16444444444e-05 1.52 2.17888888889e-05 1.54 2.19333333333e-05 1.56 2.20777777778e-05 1.58 2.22222222222e-05 1.6 2.23666666667e-05 1.62
+ 2.25111111111e-05 1.64 2.26555555556e-05 1.66 2.28e-05 1.68 2.29444444444e-05 1.7 2.30888888889e-05 1.72 2.32333333333e-05 1.74
+ 2.33777777778e-05 1.76 2.35222222222e-05 1.78 2.36666666667e-05 1.8 2.38111111111e-05 1.82 2.39555555556e-05 1.84 2.41e-05 1.86
+ 2.42444444444e-05 1.88 2.43888888889e-05 1.9 2.45333333333e-05 1.92 2.46777777778e-05 1.94 2.48222222222e-05 1.96 2.49666666667e-05 1.98
+ 2.51111111111e-05 2 2.52555555556e-05 2.02 2.54e-05 2.04 2.55444444444e-05 2.06 2.56888888889e-05 2.08 2.58333333333e-05 2.1
+ 2.59777777778e-05 2.12 2.61222222222e-05 2.14 2.62666666667e-05 2.16 2.64111111111e-05 2.18 2.65555555556e-05 2.2 2.67e-05 2.22
+ 2.68444444444e-05 2.24 2.69888888889e-05 2.26 2.71333333333e-05 2.28 2.72777777778e-05 2.3 2.74222222222e-05 2.32 2.75666666667e-05 2.34
+ 2.77111111111e-05 2.36 2.78555555556e-05 2.38 2.8e-05 2.4 2.9e-05 0)
Vd_bh5 d_bh5 0 pwl(
+ 0 0 4e-07 0 5e-07 0.05 2.91e-05 0.05 2.92e-05 0)
Xbh5 g_bh5 d_bh5 0 0 fefet_b16 x0_1=0.297536566 x0_2=-0.271436962 x0_3=-0.22265841 x0_4=-0.179678028 x0_5=-0.146825874 x0_6=-0.12104344
+ x0_7=-0.0998549702 x0_8=-0.081684736 x0_9=-0.0656050025 x0_10=-0.0511330719 x0_11=-0.0380691753 x0_12=-0.0264272707
+ x0_13=-0.0163825537 x0_14=-0.00828112591 x0_15=-0.00265407502 x0_16=-0.000142689132
.ic v(xbh5.m)=-0.383006482
Vg_cl0 g_cl0 0 pwl(
+ 0 0 1e-06 0 2e-06 -1.2 2.14444444444e-06 -1.18 2.28888888889e-06 -1.16 2.43333333333e-06 -1.14
+ 2.57777777778e-06 -1.12 2.72222222222e-06 -1.1 2.86666666667e-06 -1.08 3.01111111111e-06 -1.06 3.15555555556e-06 -1.04 3.3e-06 -1.02
+ 3.44444444444e-06 -1 3.58888888889e-06 -0.98 3.73333333333e-06 -0.96 3.87777777778e-06 -0.94 4.02222222222e-06 -0.92 4.16666666667e-06 -0.9
+ 4.31111111111e-06 -0.88 4.45555555556e-06 -0.86 4.6e-06 -0.84 4.74444444444e-06 -0.82 4.88888888889e-06 -0.8 5.03333333333e-06 -0.78
+ 5.17777777778e-06 -0.76 5.32222222222e-06 -0.74 5.46666666667e-06 -0.72 5.61111111111e-06 -0.7 5.75555555556e-06 -0.68 5.9e-06 -0.66
+ 6.04444444444e-06 -0.64 6.18888888889e-06 -0.62 6.33333333333e-06 -0.6 6.47777777778e-06 -0.58 6.62222222222e-06 -0.56 6.76666666667e-06 -0.54
+ 6.91111111111e-06 -0.52 7.05555555556e-06 -0.5 7.2e-06 -0.48 7.34444444444e-06 -0.46 7.48888888889e-06 -0.44 7.63333333333e-06 -0.42
+ 7.77777777778e-06 -0.4 7.92222222222e-06 -0.38 8.06666666667e-06 -0.36 8.21111111111e-06 -0.34 8.35555555556e-06 -0.32 8.5e-06 -0.3
+ 8.64444444444e-06 -0.28 8.78888888889e-06 -0.26 8.93333333333e-06 -0.24 9.07777777778e-06 -0.22 9.22222222222e-06 -0.2 9.36666666667e-06 -0.18
+ 9.51111111111e-06 -0.16 9.65555555556e-06 -0.14 9.8e-06 -0.12 9.94444444444e-06 -0.1 1.00888888889e-05 -0.08 1.02333333333e-05 -0.06
+ 1.03777777778e-05 -0.04 1.05222222222e-05 -0.02 1.06666666667e-05 -2.22045e-16 1.08111111111e-05 0.02 1.09555555556e-05 0.04 1.11e-05 0.06
+ 1.12444444444e-05 0.08 1.13888888889e-05 0.1 1.15333333333e-05 0.12 1.16777777778e-05 0.14 1.18222222222e-05 0.16 1.19666666667e-05 0.18
+ 1.21111111111e-05 0.2 1.22555555556e-05 0.22 1.24e-05 0.24 1.25444444444e-05 0.26 1.26888888889e-05 0.28 1.28333333333e-05 0.3
+ 1.29777777778e-05 0.32 1.31222222222e-05 0.34 1.32666666667e-05 0.36 1.34111111111e-05 0.38 1.35555555556e-05 0.4 1.37e-05 0.42
+ 1.38444444444e-05 0.44 1.39888888889e-05 0.46 1.41333333333e-05 0.48 1.42777777778e-05 0.5 1.44222222222e-05 0.52 1.45666666667e-05 0.54
+ 1.47111111111e-05 0.56 1.48555555556e-05 0.58 1.5e-05 0.6 1.51444444444e-05 0.62 1.52888888889e-05 0.64 1.54333333333e-05 0.66
+ 1.55777777778e-05 0.68 1.57222222222e-05 0.7 1.58666666667e-05 0.72 1.60111111111e-05 0.74 1.61555555556e-05 0.76 1.63e-05 0.78
+ 1.64444444444e-05 0.8 1.65888888889e-05 0.82 1.67333333333e-05 0.84 1.68777777778e-05 0.86 1.70222222222e-05 0.88 1.71666666667e-05 0.9
+ 1.73111111111e-05 0.92 1.74555555556e-05 0.94 1.76e-05 0.96 1.77444444444e-05 0.98 1.78888888889e-05 1 1.80333333333e-05 1.02
+ 1.81777777778e-05 1.04 1.83222222222e-05 1.06 1.84666666667e-05 1.08 1.86111111111e-05 1.1 1.87555555556e-05 1.12 1.89e-05 1.14
+ 1.90444444444e-05 1.16 1.91888888889e-05 1.18 1.93333333333e-05 1.2 1.94777777778e-05 1.22 1.96222222222e-05 1.24 1.97666666667e-05 1.26
+ 1.99111111111e-05 1.28 2.00555555556e-05 1.3 2.02e-05 1.32 2.03444444444e-05 1.34 2.04888888889e-05 1.36 2.06333333333e-05 1.38
+ 2.07777777778e-05 1.4 2.09222222222e-05 1.42 2.10666666667e-05 1.44 2.12111111111e-05 1.46 2.13555555556e-05 1.48 2.15e-05 1.5
+ 2.16444444444e-05 1.52 2.17888888889e-05 1.54 2.19333333333e-05 1.56 2.20777777778e-05 1.58 2.22222222222e-05 1.6 2.23666666667e-05 1.62
+ 2.25111111111e-05 1.64 2.26555555556e-05 1.66 2.28e-05 1.68 2.29444444444e-05 1.7 2.30888888889e-05 1.72 2.32333333333e-05 1.74
+ 2.33777777778e-05 1.76 2.35222222222e-05 1.78 2.36666666667e-05 1.8 2.38111111111e-05 1.82 2.39555555556e-05 1.84 2.41e-05 1.86
+ 2.42444444444e-05 1.88 2.43888888889e-05 1.9 2.45333333333e-05 1.92 2.46777777778e-05 1.94 2.48222222222e-05 1.96 2.49666666667e-05 1.98
+ 2.51111111111e-05 2 2.52555555556e-05 2.02 2.54e-05 2.04 2.55444444444e-05 2.06 2.56888888889e-05 2.08 2.58333333333e-05 2.1
+ 2.59777777778e-05 2.12 2.61222222222e-05 2.14 2.62666666667e-05 2.16 2.64111111111e-05 2.18 2.65555555556e-05 2.2 2.67e-05 2.22
+ 2.68444444444e-05 2.24 2.69888888889e-05 2.26 2.71333333333e-05 2.28 2.72777777778e-05 2.3 2.74222222222e-05 2.32 2.75666666667e-05 2.34
+ 2.77111111111e-05 2.36 2.78555555556e-05 2.38 2.8e-05 2.4 2.9e-05 0)
Vd_cl0 d_cl0 0 pwl(
+ 0 0 4e-07 0 5e-07 0.05 2.91e-05 0.05 2.92e-05 0)
Xcl0 g_cl0 d_cl0 0 0 fefet_c16 x0_1=1 x0_2=1 x0_3=1 x0_4=1 x0_5=1 x0_6=1
+ x0_7=1 x0_8=1 x0_9=1 x0_10=1 x0_11=1 x0_12=1
+ x0_13=1 x0_14=0.999999988 x0_15=1.00000021 x0_16=0.999959662
.ic v(xcl0.m)=0.424804359
Vg_cl1 g_cl1 0 pwl(
+ 0 0 1e-06 0 2e-06 -1.2 2.14444444444e-06 -1.18 2.28888888889e-06 -1.16 2.43333333333e-06 -1.14
+ 2.57777777778e-06 -1.12 2.72222222222e-06 -1.1 2.86666666667e-06 -1.08 3.01111111111e-06 -1.06 3.15555555556e-06 -1.04 3.3e-06 -1.02
+ 3.44444444444e-06 -1 3.58888888889e-06 -0.98 3.73333333333e-06 -0.96 3.87777777778e-06 -0.94 4.02222222222e-06 -0.92 4.16666666667e-06 -0.9
+ 4.31111111111e-06 -0.88 4.45555555556e-06 -0.86 4.6e-06 -0.84 4.74444444444e-06 -0.82 4.88888888889e-06 -0.8 5.03333333333e-06 -0.78
+ 5.17777777778e-06 -0.76 5.32222222222e-06 -0.74 5.46666666667e-06 -0.72 5.61111111111e-06 -0.7 5.75555555556e-06 -0.68 5.9e-06 -0.66
+ 6.04444444444e-06 -0.64 6.18888888889e-06 -0.62 6.33333333333e-06 -0.6 6.47777777778e-06 -0.58 6.62222222222e-06 -0.56 6.76666666667e-06 -0.54
+ 6.91111111111e-06 -0.52 7.05555555556e-06 -0.5 7.2e-06 -0.48 7.34444444444e-06 -0.46 7.48888888889e-06 -0.44 7.63333333333e-06 -0.42
+ 7.77777777778e-06 -0.4 7.92222222222e-06 -0.38 8.06666666667e-06 -0.36 8.21111111111e-06 -0.34 8.35555555556e-06 -0.32 8.5e-06 -0.3
+ 8.64444444444e-06 -0.28 8.78888888889e-06 -0.26 8.93333333333e-06 -0.24 9.07777777778e-06 -0.22 9.22222222222e-06 -0.2 9.36666666667e-06 -0.18
+ 9.51111111111e-06 -0.16 9.65555555556e-06 -0.14 9.8e-06 -0.12 9.94444444444e-06 -0.1 1.00888888889e-05 -0.08 1.02333333333e-05 -0.06
+ 1.03777777778e-05 -0.04 1.05222222222e-05 -0.02 1.06666666667e-05 -2.22045e-16 1.08111111111e-05 0.02 1.09555555556e-05 0.04 1.11e-05 0.06
+ 1.12444444444e-05 0.08 1.13888888889e-05 0.1 1.15333333333e-05 0.12 1.16777777778e-05 0.14 1.18222222222e-05 0.16 1.19666666667e-05 0.18
+ 1.21111111111e-05 0.2 1.22555555556e-05 0.22 1.24e-05 0.24 1.25444444444e-05 0.26 1.26888888889e-05 0.28 1.28333333333e-05 0.3
+ 1.29777777778e-05 0.32 1.31222222222e-05 0.34 1.32666666667e-05 0.36 1.34111111111e-05 0.38 1.35555555556e-05 0.4 1.37e-05 0.42
+ 1.38444444444e-05 0.44 1.39888888889e-05 0.46 1.41333333333e-05 0.48 1.42777777778e-05 0.5 1.44222222222e-05 0.52 1.45666666667e-05 0.54
+ 1.47111111111e-05 0.56 1.48555555556e-05 0.58 1.5e-05 0.6 1.51444444444e-05 0.62 1.52888888889e-05 0.64 1.54333333333e-05 0.66
+ 1.55777777778e-05 0.68 1.57222222222e-05 0.7 1.58666666667e-05 0.72 1.60111111111e-05 0.74 1.61555555556e-05 0.76 1.63e-05 0.78
+ 1.64444444444e-05 0.8 1.65888888889e-05 0.82 1.67333333333e-05 0.84 1.68777777778e-05 0.86 1.70222222222e-05 0.88 1.71666666667e-05 0.9
+ 1.73111111111e-05 0.92 1.74555555556e-05 0.94 1.76e-05 0.96 1.77444444444e-05 0.98 1.78888888889e-05 1 1.80333333333e-05 1.02
+ 1.81777777778e-05 1.04 1.83222222222e-05 1.06 1.84666666667e-05 1.08 1.86111111111e-05 1.1 1.87555555556e-05 1.12 1.89e-05 1.14
+ 1.90444444444e-05 1.16 1.91888888889e-05 1.18 1.93333333333e-05 1.2 1.94777777778e-05 1.22 1.96222222222e-05 1.24 1.97666666667e-05 1.26
+ 1.99111111111e-05 1.28 2.00555555556e-05 1.3 2.02e-05 1.32 2.03444444444e-05 1.34 2.04888888889e-05 1.36 2.06333333333e-05 1.38
+ 2.07777777778e-05 1.4 2.09222222222e-05 1.42 2.10666666667e-05 1.44 2.12111111111e-05 1.46 2.13555555556e-05 1.48 2.15e-05 1.5
+ 2.16444444444e-05 1.52 2.17888888889e-05 1.54 2.19333333333e-05 1.56 2.20777777778e-05 1.58 2.22222222222e-05 1.6 2.23666666667e-05 1.62
+ 2.25111111111e-05 1.64 2.26555555556e-05 1.66 2.28e-05 1.68 2.29444444444e-05 1.7 2.30888888889e-05 1.72 2.32333333333e-05 1.74
+ 2.33777777778e-05 1.76 2.35222222222e-05 1.78 2.36666666667e-05 1.8 2.38111111111e-05 1.82 2.39555555556e-05 1.84 2.41e-05 1.86
+ 2.42444444444e-05 1.88 2.43888888889e-05 1.9 2.45333333333e-05 1.92 2.46777777778e-05 1.94 2.48222222222e-05 1.96 2.49666666667e-05 1.98
+ 2.51111111111e-05 2 2.52555555556e-05 2.02 2.54e-05 2.04 2.55444444444e-05 2.06 2.56888888889e-05 2.08 2.58333333333e-05 2.1
+ 2.59777777778e-05 2.12 2.61222222222e-05 2.14 2.62666666667e-05 2.16 2.64111111111e-05 2.18 2.65555555556e-05 2.2 2.67e-05 2.22
+ 2.68444444444e-05 2.24 2.69888888889e-05 2.26 2.71333333333e-05 2.28 2.72777777778e-05 2.3 2.74222222222e-05 2.32 2.75666666667e-05 2.34
+ 2.77111111111e-05 2.36 2.78555555556e-05 2.38 2.8e-05 2.4 2.9e-05 0)
Vd_cl1 d_cl1 0 pwl(
+ 0 0 4e-07 0 5e-07 0.05 2.91e-05 0.05 2.92e-05 0)
Xcl1 g_cl1 d_cl1 0 0 fefet_c16 x0_1=1 x0_2=1 x0_3=1 x0_4=1 x0_5=1 x0_6=1
+ x0_7=1 x0_8=1 x0_9=1 x0_10=1 x0_11=1 x0_12=1
+ x0_13=1 x0_14=0.999999988 x0_15=1.00000021 x0_16=0.999959662
.ic v(xcl1.m)=0.424804354
Vg_cl2 g_cl2 0 pwl(
+ 0 0 1e-06 0 2e-06 -1.2 2.14444444444e-06 -1.18 2.28888888889e-06 -1.16 2.43333333333e-06 -1.14
+ 2.57777777778e-06 -1.12 2.72222222222e-06 -1.1 2.86666666667e-06 -1.08 3.01111111111e-06 -1.06 3.15555555556e-06 -1.04 3.3e-06 -1.02
+ 3.44444444444e-06 -1 3.58888888889e-06 -0.98 3.73333333333e-06 -0.96 3.87777777778e-06 -0.94 4.02222222222e-06 -0.92 4.16666666667e-06 -0.9
+ 4.31111111111e-06 -0.88 4.45555555556e-06 -0.86 4.6e-06 -0.84 4.74444444444e-06 -0.82 4.88888888889e-06 -0.8 5.03333333333e-06 -0.78
+ 5.17777777778e-06 -0.76 5.32222222222e-06 -0.74 5.46666666667e-06 -0.72 5.61111111111e-06 -0.7 5.75555555556e-06 -0.68 5.9e-06 -0.66
+ 6.04444444444e-06 -0.64 6.18888888889e-06 -0.62 6.33333333333e-06 -0.6 6.47777777778e-06 -0.58 6.62222222222e-06 -0.56 6.76666666667e-06 -0.54
+ 6.91111111111e-06 -0.52 7.05555555556e-06 -0.5 7.2e-06 -0.48 7.34444444444e-06 -0.46 7.48888888889e-06 -0.44 7.63333333333e-06 -0.42
+ 7.77777777778e-06 -0.4 7.92222222222e-06 -0.38 8.06666666667e-06 -0.36 8.21111111111e-06 -0.34 8.35555555556e-06 -0.32 8.5e-06 -0.3
+ 8.64444444444e-06 -0.28 8.78888888889e-06 -0.26 8.93333333333e-06 -0.24 9.07777777778e-06 -0.22 9.22222222222e-06 -0.2 9.36666666667e-06 -0.18
+ 9.51111111111e-06 -0.16 9.65555555556e-06 -0.14 9.8e-06 -0.12 9.94444444444e-06 -0.1 1.00888888889e-05 -0.08 1.02333333333e-05 -0.06
+ 1.03777777778e-05 -0.04 1.05222222222e-05 -0.02 1.06666666667e-05 -2.22045e-16 1.08111111111e-05 0.02 1.09555555556e-05 0.04 1.11e-05 0.06
+ 1.12444444444e-05 0.08 1.13888888889e-05 0.1 1.15333333333e-05 0.12 1.16777777778e-05 0.14 1.18222222222e-05 0.16 1.19666666667e-05 0.18
+ 1.21111111111e-05 0.2 1.22555555556e-05 0.22 1.24e-05 0.24 1.25444444444e-05 0.26 1.26888888889e-05 0.28 1.28333333333e-05 0.3
+ 1.29777777778e-05 0.32 1.31222222222e-05 0.34 1.32666666667e-05 0.36 1.34111111111e-05 0.38 1.35555555556e-05 0.4 1.37e-05 0.42
+ 1.38444444444e-05 0.44 1.39888888889e-05 0.46 1.41333333333e-05 0.48 1.42777777778e-05 0.5 1.44222222222e-05 0.52 1.45666666667e-05 0.54
+ 1.47111111111e-05 0.56 1.48555555556e-05 0.58 1.5e-05 0.6 1.51444444444e-05 0.62 1.52888888889e-05 0.64 1.54333333333e-05 0.66
+ 1.55777777778e-05 0.68 1.57222222222e-05 0.7 1.58666666667e-05 0.72 1.60111111111e-05 0.74 1.61555555556e-05 0.76 1.63e-05 0.78
+ 1.64444444444e-05 0.8 1.65888888889e-05 0.82 1.67333333333e-05 0.84 1.68777777778e-05 0.86 1.70222222222e-05 0.88 1.71666666667e-05 0.9
+ 1.73111111111e-05 0.92 1.74555555556e-05 0.94 1.76e-05 0.96 1.77444444444e-05 0.98 1.78888888889e-05 1 1.80333333333e-05 1.02
+ 1.81777777778e-05 1.04 1.83222222222e-05 1.06 1.84666666667e-05 1.08 1.86111111111e-05 1.1 1.87555555556e-05 1.12 1.89e-05 1.14
+ 1.90444444444e-05 1.16 1.91888888889e-05 1.18 1.93333333333e-05 1.2 1.94777777778e-05 1.22 1.96222222222e-05 1.24 1.97666666667e-05 1.26
+ 1.99111111111e-05 1.28 2.00555555556e-05 1.3 2.02e-05 1.32 2.03444444444e-05 1.34 2.04888888889e-05 1.36 2.06333333333e-05 1.38
+ 2.07777777778e-05 1.4 2.09222222222e-05 1.42 2.10666666667e-05 1.44 2.12111111111e-05 1.46 2.13555555556e-05 1.48 2.15e-05 1.5
+ 2.16444444444e-05 1.52 2.17888888889e-05 1.54 2.19333333333e-05 1.56 2.20777777778e-05 1.58 2.22222222222e-05 1.6 2.23666666667e-05 1.62
+ 2.25111111111e-05 1.64 2.26555555556e-05 1.66 2.28e-05 1.68 2.29444444444e-05 1.7 2.30888888889e-05 1.72 2.32333333333e-05 1.74
+ 2.33777777778e-05 1.76 2.35222222222e-05 1.78 2.36666666667e-05 1.8 2.38111111111e-05 1.82 2.39555555556e-05 1.84 2.41e-05 1.86
+ 2.42444444444e-05 1.88 2.43888888889e-05 1.9 2.45333333333e-05 1.92 2.46777777778e-05 1.94 2.48222222222e-05 1.96 2.49666666667e-05 1.98
+ 2.51111111111e-05 2 2.52555555556e-05 2.02 2.54e-05 2.04 2.55444444444e-05 2.06 2.56888888889e-05 2.08 2.58333333333e-05 2.1
+ 2.59777777778e-05 2.12 2.61222222222e-05 2.14 2.62666666667e-05 2.16 2.64111111111e-05 2.18 2.65555555556e-05 2.2 2.67e-05 2.22
+ 2.68444444444e-05 2.24 2.69888888889e-05 2.26 2.71333333333e-05 2.28 2.72777777778e-05 2.3 2.74222222222e-05 2.32 2.75666666667e-05 2.34
+ 2.77111111111e-05 2.36 2.78555555556e-05 2.38 2.8e-05 2.4 2.9e-05 0)
Vd_cl2 d_cl2 0 pwl(
+ 0 0 4e-07 0 5e-07 0.05 2.91e-05 0.05 2.92e-05 0)
Xcl2 g_cl2 d_cl2 0 0 fefet_c16 x0_1=1 x0_2=1 x0_3=1 x0_4=1 x0_5=1 x0_6=1
+ x0_7=1 x0_8=1 x0_9=1 x0_10=1 x0_11=1 x0_12=1
+ x0_13=1 x0_14=0.999999988 x0_15=1.00000021 x0_16=0.999959662
.ic v(xcl2.m)=0.424804305
Vg_cl3 g_cl3 0 pwl(
+ 0 0 1e-06 0 2e-06 -1.2 2.14444444444e-06 -1.18 2.28888888889e-06 -1.16 2.43333333333e-06 -1.14
+ 2.57777777778e-06 -1.12 2.72222222222e-06 -1.1 2.86666666667e-06 -1.08 3.01111111111e-06 -1.06 3.15555555556e-06 -1.04 3.3e-06 -1.02
+ 3.44444444444e-06 -1 3.58888888889e-06 -0.98 3.73333333333e-06 -0.96 3.87777777778e-06 -0.94 4.02222222222e-06 -0.92 4.16666666667e-06 -0.9
+ 4.31111111111e-06 -0.88 4.45555555556e-06 -0.86 4.6e-06 -0.84 4.74444444444e-06 -0.82 4.88888888889e-06 -0.8 5.03333333333e-06 -0.78
+ 5.17777777778e-06 -0.76 5.32222222222e-06 -0.74 5.46666666667e-06 -0.72 5.61111111111e-06 -0.7 5.75555555556e-06 -0.68 5.9e-06 -0.66
+ 6.04444444444e-06 -0.64 6.18888888889e-06 -0.62 6.33333333333e-06 -0.6 6.47777777778e-06 -0.58 6.62222222222e-06 -0.56 6.76666666667e-06 -0.54
+ 6.91111111111e-06 -0.52 7.05555555556e-06 -0.5 7.2e-06 -0.48 7.34444444444e-06 -0.46 7.48888888889e-06 -0.44 7.63333333333e-06 -0.42
+ 7.77777777778e-06 -0.4 7.92222222222e-06 -0.38 8.06666666667e-06 -0.36 8.21111111111e-06 -0.34 8.35555555556e-06 -0.32 8.5e-06 -0.3
+ 8.64444444444e-06 -0.28 8.78888888889e-06 -0.26 8.93333333333e-06 -0.24 9.07777777778e-06 -0.22 9.22222222222e-06 -0.2 9.36666666667e-06 -0.18
+ 9.51111111111e-06 -0.16 9.65555555556e-06 -0.14 9.8e-06 -0.12 9.94444444444e-06 -0.1 1.00888888889e-05 -0.08 1.02333333333e-05 -0.06
+ 1.03777777778e-05 -0.04 1.05222222222e-05 -0.02 1.06666666667e-05 -2.22045e-16 1.08111111111e-05 0.02 1.09555555556e-05 0.04 1.11e-05 0.06
+ 1.12444444444e-05 0.08 1.13888888889e-05 0.1 1.15333333333e-05 0.12 1.16777777778e-05 0.14 1.18222222222e-05 0.16 1.19666666667e-05 0.18
+ 1.21111111111e-05 0.2 1.22555555556e-05 0.22 1.24e-05 0.24 1.25444444444e-05 0.26 1.26888888889e-05 0.28 1.28333333333e-05 0.3
+ 1.29777777778e-05 0.32 1.31222222222e-05 0.34 1.32666666667e-05 0.36 1.34111111111e-05 0.38 1.35555555556e-05 0.4 1.37e-05 0.42
+ 1.38444444444e-05 0.44 1.39888888889e-05 0.46 1.41333333333e-05 0.48 1.42777777778e-05 0.5 1.44222222222e-05 0.52 1.45666666667e-05 0.54
+ 1.47111111111e-05 0.56 1.48555555556e-05 0.58 1.5e-05 0.6 1.51444444444e-05 0.62 1.52888888889e-05 0.64 1.54333333333e-05 0.66
+ 1.55777777778e-05 0.68 1.57222222222e-05 0.7 1.58666666667e-05 0.72 1.60111111111e-05 0.74 1.61555555556e-05 0.76 1.63e-05 0.78
+ 1.64444444444e-05 0.8 1.65888888889e-05 0.82 1.67333333333e-05 0.84 1.68777777778e-05 0.86 1.70222222222e-05 0.88 1.71666666667e-05 0.9
+ 1.73111111111e-05 0.92 1.74555555556e-05 0.94 1.76e-05 0.96 1.77444444444e-05 0.98 1.78888888889e-05 1 1.80333333333e-05 1.02
+ 1.81777777778e-05 1.04 1.83222222222e-05 1.06 1.84666666667e-05 1.08 1.86111111111e-05 1.1 1.87555555556e-05 1.12 1.89e-05 1.14
+ 1.90444444444e-05 1.16 1.91888888889e-05 1.18 1.93333333333e-05 1.2 1.94777777778e-05 1.22 1.96222222222e-05 1.24 1.97666666667e-05 1.26
+ 1.99111111111e-05 1.28 2.00555555556e-05 1.3 2.02e-05 1.32 2.03444444444e-05 1.34 2.04888888889e-05 1.36 2.06333333333e-05 1.38
+ 2.07777777778e-05 1.4 2.09222222222e-05 1.42 2.10666666667e-05 1.44 2.12111111111e-05 1.46 2.13555555556e-05 1.48 2.15e-05 1.5
+ 2.16444444444e-05 1.52 2.17888888889e-05 1.54 2.19333333333e-05 1.56 2.20777777778e-05 1.58 2.22222222222e-05 1.6 2.23666666667e-05 1.62
+ 2.25111111111e-05 1.64 2.26555555556e-05 1.66 2.28e-05 1.68 2.29444444444e-05 1.7 2.30888888889e-05 1.72 2.32333333333e-05 1.74
+ 2.33777777778e-05 1.76 2.35222222222e-05 1.78 2.36666666667e-05 1.8 2.38111111111e-05 1.82 2.39555555556e-05 1.84 2.41e-05 1.86
+ 2.42444444444e-05 1.88 2.43888888889e-05 1.9 2.45333333333e-05 1.92 2.46777777778e-05 1.94 2.48222222222e-05 1.96 2.49666666667e-05 1.98
+ 2.51111111111e-05 2 2.52555555556e-05 2.02 2.54e-05 2.04 2.55444444444e-05 2.06 2.56888888889e-05 2.08 2.58333333333e-05 2.1
+ 2.59777777778e-05 2.12 2.61222222222e-05 2.14 2.62666666667e-05 2.16 2.64111111111e-05 2.18 2.65555555556e-05 2.2 2.67e-05 2.22
+ 2.68444444444e-05 2.24 2.69888888889e-05 2.26 2.71333333333e-05 2.28 2.72777777778e-05 2.3 2.74222222222e-05 2.32 2.75666666667e-05 2.34
+ 2.77111111111e-05 2.36 2.78555555556e-05 2.38 2.8e-05 2.4 2.9e-05 0)
Vd_cl3 d_cl3 0 pwl(
+ 0 0 4e-07 0 5e-07 0.05 2.91e-05 0.05 2.92e-05 0)
Xcl3 g_cl3 d_cl3 0 0 fefet_c16 x0_1=1 x0_2=1 x0_3=1 x0_4=1 x0_5=1 x0_6=1
+ x0_7=1 x0_8=1 x0_9=1 x0_10=1 x0_11=1 x0_12=1
+ x0_13=1 x0_14=0.999999988 x0_15=1.00000021 x0_16=0.999959662
.ic v(xcl3.m)=0.42480382
Vg_cl4 g_cl4 0 pwl(
+ 0 0 1e-06 0 2e-06 -1.2 2.14444444444e-06 -1.18 2.28888888889e-06 -1.16 2.43333333333e-06 -1.14
+ 2.57777777778e-06 -1.12 2.72222222222e-06 -1.1 2.86666666667e-06 -1.08 3.01111111111e-06 -1.06 3.15555555556e-06 -1.04 3.3e-06 -1.02
+ 3.44444444444e-06 -1 3.58888888889e-06 -0.98 3.73333333333e-06 -0.96 3.87777777778e-06 -0.94 4.02222222222e-06 -0.92 4.16666666667e-06 -0.9
+ 4.31111111111e-06 -0.88 4.45555555556e-06 -0.86 4.6e-06 -0.84 4.74444444444e-06 -0.82 4.88888888889e-06 -0.8 5.03333333333e-06 -0.78
+ 5.17777777778e-06 -0.76 5.32222222222e-06 -0.74 5.46666666667e-06 -0.72 5.61111111111e-06 -0.7 5.75555555556e-06 -0.68 5.9e-06 -0.66
+ 6.04444444444e-06 -0.64 6.18888888889e-06 -0.62 6.33333333333e-06 -0.6 6.47777777778e-06 -0.58 6.62222222222e-06 -0.56 6.76666666667e-06 -0.54
+ 6.91111111111e-06 -0.52 7.05555555556e-06 -0.5 7.2e-06 -0.48 7.34444444444e-06 -0.46 7.48888888889e-06 -0.44 7.63333333333e-06 -0.42
+ 7.77777777778e-06 -0.4 7.92222222222e-06 -0.38 8.06666666667e-06 -0.36 8.21111111111e-06 -0.34 8.35555555556e-06 -0.32 8.5e-06 -0.3
+ 8.64444444444e-06 -0.28 8.78888888889e-06 -0.26 8.93333333333e-06 -0.24 9.07777777778e-06 -0.22 9.22222222222e-06 -0.2 9.36666666667e-06 -0.18
+ 9.51111111111e-06 -0.16 9.65555555556e-06 -0.14 9.8e-06 -0.12 9.94444444444e-06 -0.1 1.00888888889e-05 -0.08 1.02333333333e-05 -0.06
+ 1.03777777778e-05 -0.04 1.05222222222e-05 -0.02 1.06666666667e-05 -2.22045e-16 1.08111111111e-05 0.02 1.09555555556e-05 0.04 1.11e-05 0.06
+ 1.12444444444e-05 0.08 1.13888888889e-05 0.1 1.15333333333e-05 0.12 1.16777777778e-05 0.14 1.18222222222e-05 0.16 1.19666666667e-05 0.18
+ 1.21111111111e-05 0.2 1.22555555556e-05 0.22 1.24e-05 0.24 1.25444444444e-05 0.26 1.26888888889e-05 0.28 1.28333333333e-05 0.3
+ 1.29777777778e-05 0.32 1.31222222222e-05 0.34 1.32666666667e-05 0.36 1.34111111111e-05 0.38 1.35555555556e-05 0.4 1.37e-05 0.42
+ 1.38444444444e-05 0.44 1.39888888889e-05 0.46 1.41333333333e-05 0.48 1.42777777778e-05 0.5 1.44222222222e-05 0.52 1.45666666667e-05 0.54
+ 1.47111111111e-05 0.56 1.48555555556e-05 0.58 1.5e-05 0.6 1.51444444444e-05 0.62 1.52888888889e-05 0.64 1.54333333333e-05 0.66
+ 1.55777777778e-05 0.68 1.57222222222e-05 0.7 1.58666666667e-05 0.72 1.60111111111e-05 0.74 1.61555555556e-05 0.76 1.63e-05 0.78
+ 1.64444444444e-05 0.8 1.65888888889e-05 0.82 1.67333333333e-05 0.84 1.68777777778e-05 0.86 1.70222222222e-05 0.88 1.71666666667e-05 0.9
+ 1.73111111111e-05 0.92 1.74555555556e-05 0.94 1.76e-05 0.96 1.77444444444e-05 0.98 1.78888888889e-05 1 1.80333333333e-05 1.02
+ 1.81777777778e-05 1.04 1.83222222222e-05 1.06 1.84666666667e-05 1.08 1.86111111111e-05 1.1 1.87555555556e-05 1.12 1.89e-05 1.14
+ 1.90444444444e-05 1.16 1.91888888889e-05 1.18 1.93333333333e-05 1.2 1.94777777778e-05 1.22 1.96222222222e-05 1.24 1.97666666667e-05 1.26
+ 1.99111111111e-05 1.28 2.00555555556e-05 1.3 2.02e-05 1.32 2.03444444444e-05 1.34 2.04888888889e-05 1.36 2.06333333333e-05 1.38
+ 2.07777777778e-05 1.4 2.09222222222e-05 1.42 2.10666666667e-05 1.44 2.12111111111e-05 1.46 2.13555555556e-05 1.48 2.15e-05 1.5
+ 2.16444444444e-05 1.52 2.17888888889e-05 1.54 2.19333333333e-05 1.56 2.20777777778e-05 1.58 2.22222222222e-05 1.6 2.23666666667e-05 1.62
+ 2.25111111111e-05 1.64 2.26555555556e-05 1.66 2.28e-05 1.68 2.29444444444e-05 1.7 2.30888888889e-05 1.72 2.32333333333e-05 1.74
+ 2.33777777778e-05 1.76 2.35222222222e-05 1.78 2.36666666667e-05 1.8 2.38111111111e-05 1.82 2.39555555556e-05 1.84 2.41e-05 1.86
+ 2.42444444444e-05 1.88 2.43888888889e-05 1.9 2.45333333333e-05 1.92 2.46777777778e-05 1.94 2.48222222222e-05 1.96 2.49666666667e-05 1.98
+ 2.51111111111e-05 2 2.52555555556e-05 2.02 2.54e-05 2.04 2.55444444444e-05 2.06 2.56888888889e-05 2.08 2.58333333333e-05 2.1
+ 2.59777777778e-05 2.12 2.61222222222e-05 2.14 2.62666666667e-05 2.16 2.64111111111e-05 2.18 2.65555555556e-05 2.2 2.67e-05 2.22
+ 2.68444444444e-05 2.24 2.69888888889e-05 2.26 2.71333333333e-05 2.28 2.72777777778e-05 2.3 2.74222222222e-05 2.32 2.75666666667e-05 2.34
+ 2.77111111111e-05 2.36 2.78555555556e-05 2.38 2.8e-05 2.4 2.9e-05 0)
Vd_cl4 d_cl4 0 pwl(
+ 0 0 4e-07 0 5e-07 0.05 2.91e-05 0.05 2.92e-05 0)
Xcl4 g_cl4 d_cl4 0 0 fefet_c16 x0_1=1 x0_2=1 x0_3=1 x0_4=1 x0_5=1 x0_6=1
+ x0_7=1 x0_8=1 x0_9=1 x0_10=1 x0_11=1 x0_12=1
+ x0_13=1 x0_14=0.999999988 x0_15=1.00000021 x0_16=0.999959662
.ic v(xcl4.m)=0.42479897
Vg_cl5 g_cl5 0 pwl(
+ 0 0 1e-06 0 2e-06 -1.2 2.14444444444e-06 -1.18 2.28888888889e-06 -1.16 2.43333333333e-06 -1.14
+ 2.57777777778e-06 -1.12 2.72222222222e-06 -1.1 2.86666666667e-06 -1.08 3.01111111111e-06 -1.06 3.15555555556e-06 -1.04 3.3e-06 -1.02
+ 3.44444444444e-06 -1 3.58888888889e-06 -0.98 3.73333333333e-06 -0.96 3.87777777778e-06 -0.94 4.02222222222e-06 -0.92 4.16666666667e-06 -0.9
+ 4.31111111111e-06 -0.88 4.45555555556e-06 -0.86 4.6e-06 -0.84 4.74444444444e-06 -0.82 4.88888888889e-06 -0.8 5.03333333333e-06 -0.78
+ 5.17777777778e-06 -0.76 5.32222222222e-06 -0.74 5.46666666667e-06 -0.72 5.61111111111e-06 -0.7 5.75555555556e-06 -0.68 5.9e-06 -0.66
+ 6.04444444444e-06 -0.64 6.18888888889e-06 -0.62 6.33333333333e-06 -0.6 6.47777777778e-06 -0.58 6.62222222222e-06 -0.56 6.76666666667e-06 -0.54
+ 6.91111111111e-06 -0.52 7.05555555556e-06 -0.5 7.2e-06 -0.48 7.34444444444e-06 -0.46 7.48888888889e-06 -0.44 7.63333333333e-06 -0.42
+ 7.77777777778e-06 -0.4 7.92222222222e-06 -0.38 8.06666666667e-06 -0.36 8.21111111111e-06 -0.34 8.35555555556e-06 -0.32 8.5e-06 -0.3
+ 8.64444444444e-06 -0.28 8.78888888889e-06 -0.26 8.93333333333e-06 -0.24 9.07777777778e-06 -0.22 9.22222222222e-06 -0.2 9.36666666667e-06 -0.18
+ 9.51111111111e-06 -0.16 9.65555555556e-06 -0.14 9.8e-06 -0.12 9.94444444444e-06 -0.1 1.00888888889e-05 -0.08 1.02333333333e-05 -0.06
+ 1.03777777778e-05 -0.04 1.05222222222e-05 -0.02 1.06666666667e-05 -2.22045e-16 1.08111111111e-05 0.02 1.09555555556e-05 0.04 1.11e-05 0.06
+ 1.12444444444e-05 0.08 1.13888888889e-05 0.1 1.15333333333e-05 0.12 1.16777777778e-05 0.14 1.18222222222e-05 0.16 1.19666666667e-05 0.18
+ 1.21111111111e-05 0.2 1.22555555556e-05 0.22 1.24e-05 0.24 1.25444444444e-05 0.26 1.26888888889e-05 0.28 1.28333333333e-05 0.3
+ 1.29777777778e-05 0.32 1.31222222222e-05 0.34 1.32666666667e-05 0.36 1.34111111111e-05 0.38 1.35555555556e-05 0.4 1.37e-05 0.42
+ 1.38444444444e-05 0.44 1.39888888889e-05 0.46 1.41333333333e-05 0.48 1.42777777778e-05 0.5 1.44222222222e-05 0.52 1.45666666667e-05 0.54
+ 1.47111111111e-05 0.56 1.48555555556e-05 0.58 1.5e-05 0.6 1.51444444444e-05 0.62 1.52888888889e-05 0.64 1.54333333333e-05 0.66
+ 1.55777777778e-05 0.68 1.57222222222e-05 0.7 1.58666666667e-05 0.72 1.60111111111e-05 0.74 1.61555555556e-05 0.76 1.63e-05 0.78
+ 1.64444444444e-05 0.8 1.65888888889e-05 0.82 1.67333333333e-05 0.84 1.68777777778e-05 0.86 1.70222222222e-05 0.88 1.71666666667e-05 0.9
+ 1.73111111111e-05 0.92 1.74555555556e-05 0.94 1.76e-05 0.96 1.77444444444e-05 0.98 1.78888888889e-05 1 1.80333333333e-05 1.02
+ 1.81777777778e-05 1.04 1.83222222222e-05 1.06 1.84666666667e-05 1.08 1.86111111111e-05 1.1 1.87555555556e-05 1.12 1.89e-05 1.14
+ 1.90444444444e-05 1.16 1.91888888889e-05 1.18 1.93333333333e-05 1.2 1.94777777778e-05 1.22 1.96222222222e-05 1.24 1.97666666667e-05 1.26
+ 1.99111111111e-05 1.28 2.00555555556e-05 1.3 2.02e-05 1.32 2.03444444444e-05 1.34 2.04888888889e-05 1.36 2.06333333333e-05 1.38
+ 2.07777777778e-05 1.4 2.09222222222e-05 1.42 2.10666666667e-05 1.44 2.12111111111e-05 1.46 2.13555555556e-05 1.48 2.15e-05 1.5
+ 2.16444444444e-05 1.52 2.17888888889e-05 1.54 2.19333333333e-05 1.56 2.20777777778e-05 1.58 2.22222222222e-05 1.6 2.23666666667e-05 1.62
+ 2.25111111111e-05 1.64 2.26555555556e-05 1.66 2.28e-05 1.68 2.29444444444e-05 1.7 2.30888888889e-05 1.72 2.32333333333e-05 1.74
+ 2.33777777778e-05 1.76 2.35222222222e-05 1.78 2.36666666667e-05 1.8 2.38111111111e-05 1.82 2.39555555556e-05 1.84 2.41e-05 1.86
+ 2.42444444444e-05 1.88 2.43888888889e-05 1.9 2.45333333333e-05 1.92 2.46777777778e-05 1.94 2.48222222222e-05 1.96 2.49666666667e-05 1.98
+ 2.51111111111e-05 2 2.52555555556e-05 2.02 2.54e-05 2.04 2.55444444444e-05 2.06 2.56888888889e-05 2.08 2.58333333333e-05 2.1
+ 2.59777777778e-05 2.12 2.61222222222e-05 2.14 2.62666666667e-05 2.16 2.64111111111e-05 2.18 2.65555555556e-05 2.2 2.67e-05 2.22
+ 2.68444444444e-05 2.24 2.69888888889e-05 2.26 2.71333333333e-05 2.28 2.72777777778e-05 2.3 2.74222222222e-05 2.32 2.75666666667e-05 2.34
+ 2.77111111111e-05 2.36 2.78555555556e-05 2.38 2.8e-05 2.4 2.9e-05 0)
Vd_cl5 d_cl5 0 pwl(
+ 0 0 4e-07 0 5e-07 0.05 2.91e-05 0.05 2.92e-05 0)
Xcl5 g_cl5 d_cl5 0 0 fefet_c16 x0_1=1 x0_2=1 x0_3=1 x0_4=1 x0_5=1 x0_6=1
+ x0_7=1 x0_8=1 x0_9=1 x0_10=1 x0_11=1 x0_12=1
+ x0_13=1 x0_14=0.999999988 x0_15=1.00000021 x0_16=0.999959662
.ic v(xcl5.m)=0.424750472
Vg_ch0 g_ch0 0 pwl(
+ 0 0 1e-06 0 2e-06 -1.2 2.14444444444e-06 -1.18 2.28888888889e-06 -1.16 2.43333333333e-06 -1.14
+ 2.57777777778e-06 -1.12 2.72222222222e-06 -1.1 2.86666666667e-06 -1.08 3.01111111111e-06 -1.06 3.15555555556e-06 -1.04 3.3e-06 -1.02
+ 3.44444444444e-06 -1 3.58888888889e-06 -0.98 3.73333333333e-06 -0.96 3.87777777778e-06 -0.94 4.02222222222e-06 -0.92 4.16666666667e-06 -0.9
+ 4.31111111111e-06 -0.88 4.45555555556e-06 -0.86 4.6e-06 -0.84 4.74444444444e-06 -0.82 4.88888888889e-06 -0.8 5.03333333333e-06 -0.78
+ 5.17777777778e-06 -0.76 5.32222222222e-06 -0.74 5.46666666667e-06 -0.72 5.61111111111e-06 -0.7 5.75555555556e-06 -0.68 5.9e-06 -0.66
+ 6.04444444444e-06 -0.64 6.18888888889e-06 -0.62 6.33333333333e-06 -0.6 6.47777777778e-06 -0.58 6.62222222222e-06 -0.56 6.76666666667e-06 -0.54
+ 6.91111111111e-06 -0.52 7.05555555556e-06 -0.5 7.2e-06 -0.48 7.34444444444e-06 -0.46 7.48888888889e-06 -0.44 7.63333333333e-06 -0.42
+ 7.77777777778e-06 -0.4 7.92222222222e-06 -0.38 8.06666666667e-06 -0.36 8.21111111111e-06 -0.34 8.35555555556e-06 -0.32 8.5e-06 -0.3
+ 8.64444444444e-06 -0.28 8.78888888889e-06 -0.26 8.93333333333e-06 -0.24 9.07777777778e-06 -0.22 9.22222222222e-06 -0.2 9.36666666667e-06 -0.18
+ 9.51111111111e-06 -0.16 9.65555555556e-06 -0.14 9.8e-06 -0.12 9.94444444444e-06 -0.1 1.00888888889e-05 -0.08 1.02333333333e-05 -0.06
+ 1.03777777778e-05 -0.04 1.05222222222e-05 -0.02 1.06666666667e-05 -2.22045e-16 1.08111111111e-05 0.02 1.09555555556e-05 0.04 1.11e-05 0.06
+ 1.12444444444e-05 0.08 1.13888888889e-05 0.1 1.15333333333e-05 0.12 1.16777777778e-05 0.14 1.18222222222e-05 0.16 1.19666666667e-05 0.18
+ 1.21111111111e-05 0.2 1.22555555556e-05 0.22 1.24e-05 0.24 1.25444444444e-05 0.26 1.26888888889e-05 0.28 1.28333333333e-05 0.3
+ 1.29777777778e-05 0.32 1.31222222222e-05 0.34 1.32666666667e-05 0.36 1.34111111111e-05 0.38 1.35555555556e-05 0.4 1.37e-05 0.42
+ 1.38444444444e-05 0.44 1.39888888889e-05 0.46 1.41333333333e-05 0.48 1.42777777778e-05 0.5 1.44222222222e-05 0.52 1.45666666667e-05 0.54
+ 1.47111111111e-05 0.56 1.48555555556e-05 0.58 1.5e-05 0.6 1.51444444444e-05 0.62 1.52888888889e-05 0.64 1.54333333333e-05 0.66
+ 1.55777777778e-05 0.68 1.57222222222e-05 0.7 1.58666666667e-05 0.72 1.60111111111e-05 0.74 1.61555555556e-05 0.76 1.63e-05 0.78
+ 1.64444444444e-05 0.8 1.65888888889e-05 0.82 1.67333333333e-05 0.84 1.68777777778e-05 0.86 1.70222222222e-05 0.88 1.71666666667e-05 0.9
+ 1.73111111111e-05 0.92 1.74555555556e-05 0.94 1.76e-05 0.96 1.77444444444e-05 0.98 1.78888888889e-05 1 1.80333333333e-05 1.02
+ 1.81777777778e-05 1.04 1.83222222222e-05 1.06 1.84666666667e-05 1.08 1.86111111111e-05 1.1 1.87555555556e-05 1.12 1.89e-05 1.14
+ 1.90444444444e-05 1.16 1.91888888889e-05 1.18 1.93333333333e-05 1.2 1.94777777778e-05 1.22 1.96222222222e-05 1.24 1.97666666667e-05 1.26
+ 1.99111111111e-05 1.28 2.00555555556e-05 1.3 2.02e-05 1.32 2.03444444444e-05 1.34 2.04888888889e-05 1.36 2.06333333333e-05 1.38
+ 2.07777777778e-05 1.4 2.09222222222e-05 1.42 2.10666666667e-05 1.44 2.12111111111e-05 1.46 2.13555555556e-05 1.48 2.15e-05 1.5
+ 2.16444444444e-05 1.52 2.17888888889e-05 1.54 2.19333333333e-05 1.56 2.20777777778e-05 1.58 2.22222222222e-05 1.6 2.23666666667e-05 1.62
+ 2.25111111111e-05 1.64 2.26555555556e-05 1.66 2.28e-05 1.68 2.29444444444e-05 1.7 2.30888888889e-05 1.72 2.32333333333e-05 1.74
+ 2.33777777778e-05 1.76 2.35222222222e-05 1.78 2.36666666667e-05 1.8 2.38111111111e-05 1.82 2.39555555556e-05 1.84 2.41e-05 1.86
+ 2.42444444444e-05 1.88 2.43888888889e-05 1.9 2.45333333333e-05 1.92 2.46777777778e-05 1.94 2.48222222222e-05 1.96 2.49666666667e-05 1.98
+ 2.51111111111e-05 2 2.52555555556e-05 2.02 2.54e-05 2.04 2.55444444444e-05 2.06 2.56888888889e-05 2.08 2.58333333333e-05 2.1
+ 2.59777777778e-05 2.12 2.61222222222e-05 2.14 2.62666666667e-05 2.16 2.64111111111e-05 2.18 2.65555555556e-05 2.2 2.67e-05 2.22
+ 2.68444444444e-05 2.24 2.69888888889e-05 2.26 2.71333333333e-05 2.28 2.72777777778e-05 2.3 2.74222222222e-05 2.32 2.75666666667e-05 2.34
+ 2.77111111111e-05 2.36 2.78555555556e-05 2.38 2.8e-05 2.4 2.9e-05 0)
Vd_ch0 d_ch0 0 pwl(
+ 0 0 4e-07 0 5e-07 0.05 2.91e-05 0.05 2.92e-05 0)
Xch0 g_ch0 d_ch0 0 0 fefet_c16 x0_1=-1 x0_2=-1 x0_3=-1 x0_4=-1 x0_5=-1 x0_6=-1
+ x0_7=-1 x0_8=-1 x0_9=-1 x0_10=-1 x0_11=-1 x0_12=-1
+ x0_13=-1 x0_14=-1 x0_15=-1 x0_16=-1
.ic v(xch0.m)=-0.277154442
Vg_ch1 g_ch1 0 pwl(
+ 0 0 1e-06 0 2e-06 -1.2 2.14444444444e-06 -1.18 2.28888888889e-06 -1.16 2.43333333333e-06 -1.14
+ 2.57777777778e-06 -1.12 2.72222222222e-06 -1.1 2.86666666667e-06 -1.08 3.01111111111e-06 -1.06 3.15555555556e-06 -1.04 3.3e-06 -1.02
+ 3.44444444444e-06 -1 3.58888888889e-06 -0.98 3.73333333333e-06 -0.96 3.87777777778e-06 -0.94 4.02222222222e-06 -0.92 4.16666666667e-06 -0.9
+ 4.31111111111e-06 -0.88 4.45555555556e-06 -0.86 4.6e-06 -0.84 4.74444444444e-06 -0.82 4.88888888889e-06 -0.8 5.03333333333e-06 -0.78
+ 5.17777777778e-06 -0.76 5.32222222222e-06 -0.74 5.46666666667e-06 -0.72 5.61111111111e-06 -0.7 5.75555555556e-06 -0.68 5.9e-06 -0.66
+ 6.04444444444e-06 -0.64 6.18888888889e-06 -0.62 6.33333333333e-06 -0.6 6.47777777778e-06 -0.58 6.62222222222e-06 -0.56 6.76666666667e-06 -0.54
+ 6.91111111111e-06 -0.52 7.05555555556e-06 -0.5 7.2e-06 -0.48 7.34444444444e-06 -0.46 7.48888888889e-06 -0.44 7.63333333333e-06 -0.42
+ 7.77777777778e-06 -0.4 7.92222222222e-06 -0.38 8.06666666667e-06 -0.36 8.21111111111e-06 -0.34 8.35555555556e-06 -0.32 8.5e-06 -0.3
+ 8.64444444444e-06 -0.28 8.78888888889e-06 -0.26 8.93333333333e-06 -0.24 9.07777777778e-06 -0.22 9.22222222222e-06 -0.2 9.36666666667e-06 -0.18
+ 9.51111111111e-06 -0.16 9.65555555556e-06 -0.14 9.8e-06 -0.12 9.94444444444e-06 -0.1 1.00888888889e-05 -0.08 1.02333333333e-05 -0.06
+ 1.03777777778e-05 -0.04 1.05222222222e-05 -0.02 1.06666666667e-05 -2.22045e-16 1.08111111111e-05 0.02 1.09555555556e-05 0.04 1.11e-05 0.06
+ 1.12444444444e-05 0.08 1.13888888889e-05 0.1 1.15333333333e-05 0.12 1.16777777778e-05 0.14 1.18222222222e-05 0.16 1.19666666667e-05 0.18
+ 1.21111111111e-05 0.2 1.22555555556e-05 0.22 1.24e-05 0.24 1.25444444444e-05 0.26 1.26888888889e-05 0.28 1.28333333333e-05 0.3
+ 1.29777777778e-05 0.32 1.31222222222e-05 0.34 1.32666666667e-05 0.36 1.34111111111e-05 0.38 1.35555555556e-05 0.4 1.37e-05 0.42
+ 1.38444444444e-05 0.44 1.39888888889e-05 0.46 1.41333333333e-05 0.48 1.42777777778e-05 0.5 1.44222222222e-05 0.52 1.45666666667e-05 0.54
+ 1.47111111111e-05 0.56 1.48555555556e-05 0.58 1.5e-05 0.6 1.51444444444e-05 0.62 1.52888888889e-05 0.64 1.54333333333e-05 0.66
+ 1.55777777778e-05 0.68 1.57222222222e-05 0.7 1.58666666667e-05 0.72 1.60111111111e-05 0.74 1.61555555556e-05 0.76 1.63e-05 0.78
+ 1.64444444444e-05 0.8 1.65888888889e-05 0.82 1.67333333333e-05 0.84 1.68777777778e-05 0.86 1.70222222222e-05 0.88 1.71666666667e-05 0.9
+ 1.73111111111e-05 0.92 1.74555555556e-05 0.94 1.76e-05 0.96 1.77444444444e-05 0.98 1.78888888889e-05 1 1.80333333333e-05 1.02
+ 1.81777777778e-05 1.04 1.83222222222e-05 1.06 1.84666666667e-05 1.08 1.86111111111e-05 1.1 1.87555555556e-05 1.12 1.89e-05 1.14
+ 1.90444444444e-05 1.16 1.91888888889e-05 1.18 1.93333333333e-05 1.2 1.94777777778e-05 1.22 1.96222222222e-05 1.24 1.97666666667e-05 1.26
+ 1.99111111111e-05 1.28 2.00555555556e-05 1.3 2.02e-05 1.32 2.03444444444e-05 1.34 2.04888888889e-05 1.36 2.06333333333e-05 1.38
+ 2.07777777778e-05 1.4 2.09222222222e-05 1.42 2.10666666667e-05 1.44 2.12111111111e-05 1.46 2.13555555556e-05 1.48 2.15e-05 1.5
+ 2.16444444444e-05 1.52 2.17888888889e-05 1.54 2.19333333333e-05 1.56 2.20777777778e-05 1.58 2.22222222222e-05 1.6 2.23666666667e-05 1.62
+ 2.25111111111e-05 1.64 2.26555555556e-05 1.66 2.28e-05 1.68 2.29444444444e-05 1.7 2.30888888889e-05 1.72 2.32333333333e-05 1.74
+ 2.33777777778e-05 1.76 2.35222222222e-05 1.78 2.36666666667e-05 1.8 2.38111111111e-05 1.82 2.39555555556e-05 1.84 2.41e-05 1.86
+ 2.42444444444e-05 1.88 2.43888888889e-05 1.9 2.45333333333e-05 1.92 2.46777777778e-05 1.94 2.48222222222e-05 1.96 2.49666666667e-05 1.98
+ 2.51111111111e-05 2 2.52555555556e-05 2.02 2.54e-05 2.04 2.55444444444e-05 2.06 2.56888888889e-05 2.08 2.58333333333e-05 2.1
+ 2.59777777778e-05 2.12 2.61222222222e-05 2.14 2.62666666667e-05 2.16 2.64111111111e-05 2.18 2.65555555556e-05 2.2 2.67e-05 2.22
+ 2.68444444444e-05 2.24 2.69888888889e-05 2.26 2.71333333333e-05 2.28 2.72777777778e-05 2.3 2.74222222222e-05 2.32 2.75666666667e-05 2.34
+ 2.77111111111e-05 2.36 2.78555555556e-05 2.38 2.8e-05 2.4 2.9e-05 0)
Vd_ch1 d_ch1 0 pwl(
+ 0 0 4e-07 0 5e-07 0.05 2.91e-05 0.05 2.92e-05 0)
Xch1 g_ch1 d_ch1 0 0 fefet_c16 x0_1=-1 x0_2=-1 x0_3=-1 x0_4=-1 x0_5=-1 x0_6=-1
+ x0_7=-1 x0_8=-1 x0_9=-1 x0_10=-1 x0_11=-1 x0_12=-1
+ x0_13=-1 x0_14=-1 x0_15=-1 x0_16=-1
.ic v(xch1.m)=-0.27715444
Vg_ch2 g_ch2 0 pwl(
+ 0 0 1e-06 0 2e-06 -1.2 2.14444444444e-06 -1.18 2.28888888889e-06 -1.16 2.43333333333e-06 -1.14
+ 2.57777777778e-06 -1.12 2.72222222222e-06 -1.1 2.86666666667e-06 -1.08 3.01111111111e-06 -1.06 3.15555555556e-06 -1.04 3.3e-06 -1.02
+ 3.44444444444e-06 -1 3.58888888889e-06 -0.98 3.73333333333e-06 -0.96 3.87777777778e-06 -0.94 4.02222222222e-06 -0.92 4.16666666667e-06 -0.9
+ 4.31111111111e-06 -0.88 4.45555555556e-06 -0.86 4.6e-06 -0.84 4.74444444444e-06 -0.82 4.88888888889e-06 -0.8 5.03333333333e-06 -0.78
+ 5.17777777778e-06 -0.76 5.32222222222e-06 -0.74 5.46666666667e-06 -0.72 5.61111111111e-06 -0.7 5.75555555556e-06 -0.68 5.9e-06 -0.66
+ 6.04444444444e-06 -0.64 6.18888888889e-06 -0.62 6.33333333333e-06 -0.6 6.47777777778e-06 -0.58 6.62222222222e-06 -0.56 6.76666666667e-06 -0.54
+ 6.91111111111e-06 -0.52 7.05555555556e-06 -0.5 7.2e-06 -0.48 7.34444444444e-06 -0.46 7.48888888889e-06 -0.44 7.63333333333e-06 -0.42
+ 7.77777777778e-06 -0.4 7.92222222222e-06 -0.38 8.06666666667e-06 -0.36 8.21111111111e-06 -0.34 8.35555555556e-06 -0.32 8.5e-06 -0.3
+ 8.64444444444e-06 -0.28 8.78888888889e-06 -0.26 8.93333333333e-06 -0.24 9.07777777778e-06 -0.22 9.22222222222e-06 -0.2 9.36666666667e-06 -0.18
+ 9.51111111111e-06 -0.16 9.65555555556e-06 -0.14 9.8e-06 -0.12 9.94444444444e-06 -0.1 1.00888888889e-05 -0.08 1.02333333333e-05 -0.06
+ 1.03777777778e-05 -0.04 1.05222222222e-05 -0.02 1.06666666667e-05 -2.22045e-16 1.08111111111e-05 0.02 1.09555555556e-05 0.04 1.11e-05 0.06
+ 1.12444444444e-05 0.08 1.13888888889e-05 0.1 1.15333333333e-05 0.12 1.16777777778e-05 0.14 1.18222222222e-05 0.16 1.19666666667e-05 0.18
+ 1.21111111111e-05 0.2 1.22555555556e-05 0.22 1.24e-05 0.24 1.25444444444e-05 0.26 1.26888888889e-05 0.28 1.28333333333e-05 0.3
+ 1.29777777778e-05 0.32 1.31222222222e-05 0.34 1.32666666667e-05 0.36 1.34111111111e-05 0.38 1.35555555556e-05 0.4 1.37e-05 0.42
+ 1.38444444444e-05 0.44 1.39888888889e-05 0.46 1.41333333333e-05 0.48 1.42777777778e-05 0.5 1.44222222222e-05 0.52 1.45666666667e-05 0.54
+ 1.47111111111e-05 0.56 1.48555555556e-05 0.58 1.5e-05 0.6 1.51444444444e-05 0.62 1.52888888889e-05 0.64 1.54333333333e-05 0.66
+ 1.55777777778e-05 0.68 1.57222222222e-05 0.7 1.58666666667e-05 0.72 1.60111111111e-05 0.74 1.61555555556e-05 0.76 1.63e-05 0.78
+ 1.64444444444e-05 0.8 1.65888888889e-05 0.82 1.67333333333e-05 0.84 1.68777777778e-05 0.86 1.70222222222e-05 0.88 1.71666666667e-05 0.9
+ 1.73111111111e-05 0.92 1.74555555556e-05 0.94 1.76e-05 0.96 1.77444444444e-05 0.98 1.78888888889e-05 1 1.80333333333e-05 1.02
+ 1.81777777778e-05 1.04 1.83222222222e-05 1.06 1.84666666667e-05 1.08 1.86111111111e-05 1.1 1.87555555556e-05 1.12 1.89e-05 1.14
+ 1.90444444444e-05 1.16 1.91888888889e-05 1.18 1.93333333333e-05 1.2 1.94777777778e-05 1.22 1.96222222222e-05 1.24 1.97666666667e-05 1.26
+ 1.99111111111e-05 1.28 2.00555555556e-05 1.3 2.02e-05 1.32 2.03444444444e-05 1.34 2.04888888889e-05 1.36 2.06333333333e-05 1.38
+ 2.07777777778e-05 1.4 2.09222222222e-05 1.42 2.10666666667e-05 1.44 2.12111111111e-05 1.46 2.13555555556e-05 1.48 2.15e-05 1.5
+ 2.16444444444e-05 1.52 2.17888888889e-05 1.54 2.19333333333e-05 1.56 2.20777777778e-05 1.58 2.22222222222e-05 1.6 2.23666666667e-05 1.62
+ 2.25111111111e-05 1.64 2.26555555556e-05 1.66 2.28e-05 1.68 2.29444444444e-05 1.7 2.30888888889e-05 1.72 2.32333333333e-05 1.74
+ 2.33777777778e-05 1.76 2.35222222222e-05 1.78 2.36666666667e-05 1.8 2.38111111111e-05 1.82 2.39555555556e-05 1.84 2.41e-05 1.86
+ 2.42444444444e-05 1.88 2.43888888889e-05 1.9 2.45333333333e-05 1.92 2.46777777778e-05 1.94 2.48222222222e-05 1.96 2.49666666667e-05 1.98
+ 2.51111111111e-05 2 2.52555555556e-05 2.02 2.54e-05 2.04 2.55444444444e-05 2.06 2.56888888889e-05 2.08 2.58333333333e-05 2.1
+ 2.59777777778e-05 2.12 2.61222222222e-05 2.14 2.62666666667e-05 2.16 2.64111111111e-05 2.18 2.65555555556e-05 2.2 2.67e-05 2.22
+ 2.68444444444e-05 2.24 2.69888888889e-05 2.26 2.71333333333e-05 2.28 2.72777777778e-05 2.3 2.74222222222e-05 2.32 2.75666666667e-05 2.34
+ 2.77111111111e-05 2.36 2.78555555556e-05 2.38 2.8e-05 2.4 2.9e-05 0)
Vd_ch2 d_ch2 0 pwl(
+ 0 0 4e-07 0 5e-07 0.05 2.91e-05 0.05 2.92e-05 0)
Xch2 g_ch2 d_ch2 0 0 fefet_c16 x0_1=-1 x0_2=-1 x0_3=-1 x0_4=-1 x0_5=-1 x0_6=-1
+ x0_7=-1 x0_8=-1 x0_9=-1 x0_10=-1 x0_11=-1 x0_12=-1
+ x0_13=-1 x0_14=-1 x0_15=-1 x0_16=-1
.ic v(xch2.m)=-0.277154423
Vg_ch3 g_ch3 0 pwl(
+ 0 0 1e-06 0 2e-06 -1.2 2.14444444444e-06 -1.18 2.28888888889e-06 -1.16 2.43333333333e-06 -1.14
+ 2.57777777778e-06 -1.12 2.72222222222e-06 -1.1 2.86666666667e-06 -1.08 3.01111111111e-06 -1.06 3.15555555556e-06 -1.04 3.3e-06 -1.02
+ 3.44444444444e-06 -1 3.58888888889e-06 -0.98 3.73333333333e-06 -0.96 3.87777777778e-06 -0.94 4.02222222222e-06 -0.92 4.16666666667e-06 -0.9
+ 4.31111111111e-06 -0.88 4.45555555556e-06 -0.86 4.6e-06 -0.84 4.74444444444e-06 -0.82 4.88888888889e-06 -0.8 5.03333333333e-06 -0.78
+ 5.17777777778e-06 -0.76 5.32222222222e-06 -0.74 5.46666666667e-06 -0.72 5.61111111111e-06 -0.7 5.75555555556e-06 -0.68 5.9e-06 -0.66
+ 6.04444444444e-06 -0.64 6.18888888889e-06 -0.62 6.33333333333e-06 -0.6 6.47777777778e-06 -0.58 6.62222222222e-06 -0.56 6.76666666667e-06 -0.54
+ 6.91111111111e-06 -0.52 7.05555555556e-06 -0.5 7.2e-06 -0.48 7.34444444444e-06 -0.46 7.48888888889e-06 -0.44 7.63333333333e-06 -0.42
+ 7.77777777778e-06 -0.4 7.92222222222e-06 -0.38 8.06666666667e-06 -0.36 8.21111111111e-06 -0.34 8.35555555556e-06 -0.32 8.5e-06 -0.3
+ 8.64444444444e-06 -0.28 8.78888888889e-06 -0.26 8.93333333333e-06 -0.24 9.07777777778e-06 -0.22 9.22222222222e-06 -0.2 9.36666666667e-06 -0.18
+ 9.51111111111e-06 -0.16 9.65555555556e-06 -0.14 9.8e-06 -0.12 9.94444444444e-06 -0.1 1.00888888889e-05 -0.08 1.02333333333e-05 -0.06
+ 1.03777777778e-05 -0.04 1.05222222222e-05 -0.02 1.06666666667e-05 -2.22045e-16 1.08111111111e-05 0.02 1.09555555556e-05 0.04 1.11e-05 0.06
+ 1.12444444444e-05 0.08 1.13888888889e-05 0.1 1.15333333333e-05 0.12 1.16777777778e-05 0.14 1.18222222222e-05 0.16 1.19666666667e-05 0.18
+ 1.21111111111e-05 0.2 1.22555555556e-05 0.22 1.24e-05 0.24 1.25444444444e-05 0.26 1.26888888889e-05 0.28 1.28333333333e-05 0.3
+ 1.29777777778e-05 0.32 1.31222222222e-05 0.34 1.32666666667e-05 0.36 1.34111111111e-05 0.38 1.35555555556e-05 0.4 1.37e-05 0.42
+ 1.38444444444e-05 0.44 1.39888888889e-05 0.46 1.41333333333e-05 0.48 1.42777777778e-05 0.5 1.44222222222e-05 0.52 1.45666666667e-05 0.54
+ 1.47111111111e-05 0.56 1.48555555556e-05 0.58 1.5e-05 0.6 1.51444444444e-05 0.62 1.52888888889e-05 0.64 1.54333333333e-05 0.66
+ 1.55777777778e-05 0.68 1.57222222222e-05 0.7 1.58666666667e-05 0.72 1.60111111111e-05 0.74 1.61555555556e-05 0.76 1.63e-05 0.78
+ 1.64444444444e-05 0.8 1.65888888889e-05 0.82 1.67333333333e-05 0.84 1.68777777778e-05 0.86 1.70222222222e-05 0.88 1.71666666667e-05 0.9
+ 1.73111111111e-05 0.92 1.74555555556e-05 0.94 1.76e-05 0.96 1.77444444444e-05 0.98 1.78888888889e-05 1 1.80333333333e-05 1.02
+ 1.81777777778e-05 1.04 1.83222222222e-05 1.06 1.84666666667e-05 1.08 1.86111111111e-05 1.1 1.87555555556e-05 1.12 1.89e-05 1.14
+ 1.90444444444e-05 1.16 1.91888888889e-05 1.18 1.93333333333e-05 1.2 1.94777777778e-05 1.22 1.96222222222e-05 1.24 1.97666666667e-05 1.26
+ 1.99111111111e-05 1.28 2.00555555556e-05 1.3 2.02e-05 1.32 2.03444444444e-05 1.34 2.04888888889e-05 1.36 2.06333333333e-05 1.38
+ 2.07777777778e-05 1.4 2.09222222222e-05 1.42 2.10666666667e-05 1.44 2.12111111111e-05 1.46 2.13555555556e-05 1.48 2.15e-05 1.5
+ 2.16444444444e-05 1.52 2.17888888889e-05 1.54 2.19333333333e-05 1.56 2.20777777778e-05 1.58 2.22222222222e-05 1.6 2.23666666667e-05 1.62
+ 2.25111111111e-05 1.64 2.26555555556e-05 1.66 2.28e-05 1.68 2.29444444444e-05 1.7 2.30888888889e-05 1.72 2.32333333333e-05 1.74
+ 2.33777777778e-05 1.76 2.35222222222e-05 1.78 2.36666666667e-05 1.8 2.38111111111e-05 1.82 2.39555555556e-05 1.84 2.41e-05 1.86
+ 2.42444444444e-05 1.88 2.43888888889e-05 1.9 2.45333333333e-05 1.92 2.46777777778e-05 1.94 2.48222222222e-05 1.96 2.49666666667e-05 1.98
+ 2.51111111111e-05 2 2.52555555556e-05 2.02 2.54e-05 2.04 2.55444444444e-05 2.06 2.56888888889e-05 2.08 2.58333333333e-05 2.1
+ 2.59777777778e-05 2.12 2.61222222222e-05 2.14 2.62666666667e-05 2.16 2.64111111111e-05 2.18 2.65555555556e-05 2.2 2.67e-05 2.22
+ 2.68444444444e-05 2.24 2.69888888889e-05 2.26 2.71333333333e-05 2.28 2.72777777778e-05 2.3 2.74222222222e-05 2.32 2.75666666667e-05 2.34
+ 2.77111111111e-05 2.36 2.78555555556e-05 2.38 2.8e-05 2.4 2.9e-05 0)
Vd_ch3 d_ch3 0 pwl(
+ 0 0 4e-07 0 5e-07 0.05 2.91e-05 0.05 2.92e-05 0)
Xch3 g_ch3 d_ch3 0 0 fefet_c16 x0_1=-1 x0_2=-1 x0_3=-1 x0_4=-1 x0_5=-1 x0_6=-1
+ x0_7=-1 x0_8=-1 x0_9=-1 x0_10=-1 x0_11=-1 x0_12=-1
+ x0_13=-1 x0_14=-1 x0_15=-1 x0_16=-1
.ic v(xch3.m)=-0.277154253
Vg_ch4 g_ch4 0 pwl(
+ 0 0 1e-06 0 2e-06 -1.2 2.14444444444e-06 -1.18 2.28888888889e-06 -1.16 2.43333333333e-06 -1.14
+ 2.57777777778e-06 -1.12 2.72222222222e-06 -1.1 2.86666666667e-06 -1.08 3.01111111111e-06 -1.06 3.15555555556e-06 -1.04 3.3e-06 -1.02
+ 3.44444444444e-06 -1 3.58888888889e-06 -0.98 3.73333333333e-06 -0.96 3.87777777778e-06 -0.94 4.02222222222e-06 -0.92 4.16666666667e-06 -0.9
+ 4.31111111111e-06 -0.88 4.45555555556e-06 -0.86 4.6e-06 -0.84 4.74444444444e-06 -0.82 4.88888888889e-06 -0.8 5.03333333333e-06 -0.78
+ 5.17777777778e-06 -0.76 5.32222222222e-06 -0.74 5.46666666667e-06 -0.72 5.61111111111e-06 -0.7 5.75555555556e-06 -0.68 5.9e-06 -0.66
+ 6.04444444444e-06 -0.64 6.18888888889e-06 -0.62 6.33333333333e-06 -0.6 6.47777777778e-06 -0.58 6.62222222222e-06 -0.56 6.76666666667e-06 -0.54
+ 6.91111111111e-06 -0.52 7.05555555556e-06 -0.5 7.2e-06 -0.48 7.34444444444e-06 -0.46 7.48888888889e-06 -0.44 7.63333333333e-06 -0.42
+ 7.77777777778e-06 -0.4 7.92222222222e-06 -0.38 8.06666666667e-06 -0.36 8.21111111111e-06 -0.34 8.35555555556e-06 -0.32 8.5e-06 -0.3
+ 8.64444444444e-06 -0.28 8.78888888889e-06 -0.26 8.93333333333e-06 -0.24 9.07777777778e-06 -0.22 9.22222222222e-06 -0.2 9.36666666667e-06 -0.18
+ 9.51111111111e-06 -0.16 9.65555555556e-06 -0.14 9.8e-06 -0.12 9.94444444444e-06 -0.1 1.00888888889e-05 -0.08 1.02333333333e-05 -0.06
+ 1.03777777778e-05 -0.04 1.05222222222e-05 -0.02 1.06666666667e-05 -2.22045e-16 1.08111111111e-05 0.02 1.09555555556e-05 0.04 1.11e-05 0.06
+ 1.12444444444e-05 0.08 1.13888888889e-05 0.1 1.15333333333e-05 0.12 1.16777777778e-05 0.14 1.18222222222e-05 0.16 1.19666666667e-05 0.18
+ 1.21111111111e-05 0.2 1.22555555556e-05 0.22 1.24e-05 0.24 1.25444444444e-05 0.26 1.26888888889e-05 0.28 1.28333333333e-05 0.3
+ 1.29777777778e-05 0.32 1.31222222222e-05 0.34 1.32666666667e-05 0.36 1.34111111111e-05 0.38 1.35555555556e-05 0.4 1.37e-05 0.42
+ 1.38444444444e-05 0.44 1.39888888889e-05 0.46 1.41333333333e-05 0.48 1.42777777778e-05 0.5 1.44222222222e-05 0.52 1.45666666667e-05 0.54
+ 1.47111111111e-05 0.56 1.48555555556e-05 0.58 1.5e-05 0.6 1.51444444444e-05 0.62 1.52888888889e-05 0.64 1.54333333333e-05 0.66
+ 1.55777777778e-05 0.68 1.57222222222e-05 0.7 1.58666666667e-05 0.72 1.60111111111e-05 0.74 1.61555555556e-05 0.76 1.63e-05 0.78
+ 1.64444444444e-05 0.8 1.65888888889e-05 0.82 1.67333333333e-05 0.84 1.68777777778e-05 0.86 1.70222222222e-05 0.88 1.71666666667e-05 0.9
+ 1.73111111111e-05 0.92 1.74555555556e-05 0.94 1.76e-05 0.96 1.77444444444e-05 0.98 1.78888888889e-05 1 1.80333333333e-05 1.02
+ 1.81777777778e-05 1.04 1.83222222222e-05 1.06 1.84666666667e-05 1.08 1.86111111111e-05 1.1 1.87555555556e-05 1.12 1.89e-05 1.14
+ 1.90444444444e-05 1.16 1.91888888889e-05 1.18 1.93333333333e-05 1.2 1.94777777778e-05 1.22 1.96222222222e-05 1.24 1.97666666667e-05 1.26
+ 1.99111111111e-05 1.28 2.00555555556e-05 1.3 2.02e-05 1.32 2.03444444444e-05 1.34 2.04888888889e-05 1.36 2.06333333333e-05 1.38
+ 2.07777777778e-05 1.4 2.09222222222e-05 1.42 2.10666666667e-05 1.44 2.12111111111e-05 1.46 2.13555555556e-05 1.48 2.15e-05 1.5
+ 2.16444444444e-05 1.52 2.17888888889e-05 1.54 2.19333333333e-05 1.56 2.20777777778e-05 1.58 2.22222222222e-05 1.6 2.23666666667e-05 1.62
+ 2.25111111111e-05 1.64 2.26555555556e-05 1.66 2.28e-05 1.68 2.29444444444e-05 1.7 2.30888888889e-05 1.72 2.32333333333e-05 1.74
+ 2.33777777778e-05 1.76 2.35222222222e-05 1.78 2.36666666667e-05 1.8 2.38111111111e-05 1.82 2.39555555556e-05 1.84 2.41e-05 1.86
+ 2.42444444444e-05 1.88 2.43888888889e-05 1.9 2.45333333333e-05 1.92 2.46777777778e-05 1.94 2.48222222222e-05 1.96 2.49666666667e-05 1.98
+ 2.51111111111e-05 2 2.52555555556e-05 2.02 2.54e-05 2.04 2.55444444444e-05 2.06 2.56888888889e-05 2.08 2.58333333333e-05 2.1
+ 2.59777777778e-05 2.12 2.61222222222e-05 2.14 2.62666666667e-05 2.16 2.64111111111e-05 2.18 2.65555555556e-05 2.2 2.67e-05 2.22
+ 2.68444444444e-05 2.24 2.69888888889e-05 2.26 2.71333333333e-05 2.28 2.72777777778e-05 2.3 2.74222222222e-05 2.32 2.75666666667e-05 2.34
+ 2.77111111111e-05 2.36 2.78555555556e-05 2.38 2.8e-05 2.4 2.9e-05 0)
Vd_ch4 d_ch4 0 pwl(
+ 0 0 4e-07 0 5e-07 0.05 2.91e-05 0.05 2.92e-05 0)
Xch4 g_ch4 d_ch4 0 0 fefet_c16 x0_1=-1 x0_2=-1 x0_3=-1 x0_4=-1 x0_5=-1 x0_6=-1
+ x0_7=-1 x0_8=-1 x0_9=-1 x0_10=-1 x0_11=-1 x0_12=-1
+ x0_13=-1 x0_14=-1 x0_15=-1 x0_16=-1
.ic v(xch4.m)=-0.277152548
Vg_ch5 g_ch5 0 pwl(
+ 0 0 1e-06 0 2e-06 -1.2 2.14444444444e-06 -1.18 2.28888888889e-06 -1.16 2.43333333333e-06 -1.14
+ 2.57777777778e-06 -1.12 2.72222222222e-06 -1.1 2.86666666667e-06 -1.08 3.01111111111e-06 -1.06 3.15555555556e-06 -1.04 3.3e-06 -1.02
+ 3.44444444444e-06 -1 3.58888888889e-06 -0.98 3.73333333333e-06 -0.96 3.87777777778e-06 -0.94 4.02222222222e-06 -0.92 4.16666666667e-06 -0.9
+ 4.31111111111e-06 -0.88 4.45555555556e-06 -0.86 4.6e-06 -0.84 4.74444444444e-06 -0.82 4.88888888889e-06 -0.8 5.03333333333e-06 -0.78
+ 5.17777777778e-06 -0.76 5.32222222222e-06 -0.74 5.46666666667e-06 -0.72 5.61111111111e-06 -0.7 5.75555555556e-06 -0.68 5.9e-06 -0.66
+ 6.04444444444e-06 -0.64 6.18888888889e-06 -0.62 6.33333333333e-06 -0.6 6.47777777778e-06 -0.58 6.62222222222e-06 -0.56 6.76666666667e-06 -0.54
+ 6.91111111111e-06 -0.52 7.05555555556e-06 -0.5 7.2e-06 -0.48 7.34444444444e-06 -0.46 7.48888888889e-06 -0.44 7.63333333333e-06 -0.42
+ 7.77777777778e-06 -0.4 7.92222222222e-06 -0.38 8.06666666667e-06 -0.36 8.21111111111e-06 -0.34 8.35555555556e-06 -0.32 8.5e-06 -0.3
+ 8.64444444444e-06 -0.28 8.78888888889e-06 -0.26 8.93333333333e-06 -0.24 9.07777777778e-06 -0.22 9.22222222222e-06 -0.2 9.36666666667e-06 -0.18
+ 9.51111111111e-06 -0.16 9.65555555556e-06 -0.14 9.8e-06 -0.12 9.94444444444e-06 -0.1 1.00888888889e-05 -0.08 1.02333333333e-05 -0.06
+ 1.03777777778e-05 -0.04 1.05222222222e-05 -0.02 1.06666666667e-05 -2.22045e-16 1.08111111111e-05 0.02 1.09555555556e-05 0.04 1.11e-05 0.06
+ 1.12444444444e-05 0.08 1.13888888889e-05 0.1 1.15333333333e-05 0.12 1.16777777778e-05 0.14 1.18222222222e-05 0.16 1.19666666667e-05 0.18
+ 1.21111111111e-05 0.2 1.22555555556e-05 0.22 1.24e-05 0.24 1.25444444444e-05 0.26 1.26888888889e-05 0.28 1.28333333333e-05 0.3
+ 1.29777777778e-05 0.32 1.31222222222e-05 0.34 1.32666666667e-05 0.36 1.34111111111e-05 0.38 1.35555555556e-05 0.4 1.37e-05 0.42
+ 1.38444444444e-05 0.44 1.39888888889e-05 0.46 1.41333333333e-05 0.48 1.42777777778e-05 0.5 1.44222222222e-05 0.52 1.45666666667e-05 0.54
+ 1.47111111111e-05 0.56 1.48555555556e-05 0.58 1.5e-05 0.6 1.51444444444e-05 0.62 1.52888888889e-05 0.64 1.54333333333e-05 0.66
+ 1.55777777778e-05 0.68 1.57222222222e-05 0.7 1.58666666667e-05 0.72 1.60111111111e-05 0.74 1.61555555556e-05 0.76 1.63e-05 0.78
+ 1.64444444444e-05 0.8 1.65888888889e-05 0.82 1.67333333333e-05 0.84 1.68777777778e-05 0.86 1.70222222222e-05 0.88 1.71666666667e-05 0.9
+ 1.73111111111e-05 0.92 1.74555555556e-05 0.94 1.76e-05 0.96 1.77444444444e-05 0.98 1.78888888889e-05 1 1.80333333333e-05 1.02
+ 1.81777777778e-05 1.04 1.83222222222e-05 1.06 1.84666666667e-05 1.08 1.86111111111e-05 1.1 1.87555555556e-05 1.12 1.89e-05 1.14
+ 1.90444444444e-05 1.16 1.91888888889e-05 1.18 1.93333333333e-05 1.2 1.94777777778e-05 1.22 1.96222222222e-05 1.24 1.97666666667e-05 1.26
+ 1.99111111111e-05 1.28 2.00555555556e-05 1.3 2.02e-05 1.32 2.03444444444e-05 1.34 2.04888888889e-05 1.36 2.06333333333e-05 1.38
+ 2.07777777778e-05 1.4 2.09222222222e-05 1.42 2.10666666667e-05 1.44 2.12111111111e-05 1.46 2.13555555556e-05 1.48 2.15e-05 1.5
+ 2.16444444444e-05 1.52 2.17888888889e-05 1.54 2.19333333333e-05 1.56 2.20777777778e-05 1.58 2.22222222222e-05 1.6 2.23666666667e-05 1.62
+ 2.25111111111e-05 1.64 2.26555555556e-05 1.66 2.28e-05 1.68 2.29444444444e-05 1.7 2.30888888889e-05 1.72 2.32333333333e-05 1.74
+ 2.33777777778e-05 1.76 2.35222222222e-05 1.78 2.36666666667e-05 1.8 2.38111111111e-05 1.82 2.39555555556e-05 1.84 2.41e-05 1.86
+ 2.42444444444e-05 1.88 2.43888888889e-05 1.9 2.45333333333e-05 1.92 2.46777777778e-05 1.94 2.48222222222e-05 1.96 2.49666666667e-05 1.98
+ 2.51111111111e-05 2 2.52555555556e-05 2.02 2.54e-05 2.04 2.55444444444e-05 2.06 2.56888888889e-05 2.08 2.58333333333e-05 2.1
+ 2.59777777778e-05 2.12 2.61222222222e-05 2.14 2.62666666667e-05 2.16 2.64111111111e-05 2.18 2.65555555556e-05 2.2 2.67e-05 2.22
+ 2.68444444444e-05 2.24 2.69888888889e-05 2.26 2.71333333333e-05 2.28 2.72777777778e-05 2.3 2.74222222222e-05 2.32 2.75666666667e-05 2.34
+ 2.77111111111e-05 2.36 2.78555555556e-05 2.38 2.8e-05 2.4 2.9e-05 0)
Vd_ch5 d_ch5 0 pwl(
+ 0 0 4e-07 0 5e-07 0.05 2.91e-05 0.05 2.92e-05 0)
Xch5 g_ch5 d_ch5 0 0 fefet_c16 x0_1=-1 x0_2=-1 x0_3=-1 x0_4=-1 x0_5=-1 x0_6=-1
+ x0_7=-1 x0_8=-1 x0_9=-1 x0_10=-1 x0_11=-1 x0_12=-1
+ x0_13=-1 x0_14=-1 x0_15=-1 x0_16=-1
.ic v(xch5.m)=-0.2771355
Vg_cv0 g_cv0 0 pwl(
+ 0 0 1e-06 0 2e-06 -1.2 2.14444444444e-06 -1.18 2.28888888889e-06 -1.16 2.43333333333e-06 -1.14
+ 2.57777777778e-06 -1.12 2.72222222222e-06 -1.1 2.86666666667e-06 -1.08 3.01111111111e-06 -1.06 3.15555555556e-06 -1.04 3.3e-06 -1.02
+ 3.44444444444e-06 -1 3.58888888889e-06 -0.98 3.73333333333e-06 -0.96 3.87777777778e-06 -0.94 4.02222222222e-06 -0.92 4.16666666667e-06 -0.9
+ 4.31111111111e-06 -0.88 4.45555555556e-06 -0.86 4.6e-06 -0.84 4.74444444444e-06 -0.82 4.88888888889e-06 -0.8 5.03333333333e-06 -0.78
+ 5.17777777778e-06 -0.76 5.32222222222e-06 -0.74 5.46666666667e-06 -0.72 5.61111111111e-06 -0.7 5.75555555556e-06 -0.68 5.9e-06 -0.66
+ 6.04444444444e-06 -0.64 6.18888888889e-06 -0.62 6.33333333333e-06 -0.6 6.47777777778e-06 -0.58 6.62222222222e-06 -0.56 6.76666666667e-06 -0.54
+ 6.91111111111e-06 -0.52 7.05555555556e-06 -0.5 7.2e-06 -0.48 7.34444444444e-06 -0.46 7.48888888889e-06 -0.44 7.63333333333e-06 -0.42
+ 7.77777777778e-06 -0.4 7.92222222222e-06 -0.38 8.06666666667e-06 -0.36 8.21111111111e-06 -0.34 8.35555555556e-06 -0.32 8.5e-06 -0.3
+ 8.64444444444e-06 -0.28 8.78888888889e-06 -0.26 8.93333333333e-06 -0.24 9.07777777778e-06 -0.22 9.22222222222e-06 -0.2 9.36666666667e-06 -0.18
+ 9.51111111111e-06 -0.16 9.65555555556e-06 -0.14 9.8e-06 -0.12 9.94444444444e-06 -0.1 1.00888888889e-05 -0.08 1.02333333333e-05 -0.06
+ 1.03777777778e-05 -0.04 1.05222222222e-05 -0.02 1.06666666667e-05 -2.22045e-16 1.08111111111e-05 0.02 1.09555555556e-05 0.04 1.11e-05 0.06
+ 1.12444444444e-05 0.08 1.13888888889e-05 0.1 1.15333333333e-05 0.12 1.16777777778e-05 0.14 1.18222222222e-05 0.16 1.19666666667e-05 0.18
+ 1.21111111111e-05 0.2 1.22555555556e-05 0.22 1.24e-05 0.24 1.25444444444e-05 0.26 1.26888888889e-05 0.28 1.28333333333e-05 0.3
+ 1.29777777778e-05 0.32 1.31222222222e-05 0.34 1.32666666667e-05 0.36 1.34111111111e-05 0.38 1.35555555556e-05 0.4 1.37e-05 0.42
+ 1.38444444444e-05 0.44 1.39888888889e-05 0.46 1.41333333333e-05 0.48 1.42777777778e-05 0.5 1.44222222222e-05 0.52 1.45666666667e-05 0.54
+ 1.47111111111e-05 0.56 1.48555555556e-05 0.58 1.5e-05 0.6 1.51444444444e-05 0.62 1.52888888889e-05 0.64 1.54333333333e-05 0.66
+ 1.55777777778e-05 0.68 1.57222222222e-05 0.7 1.58666666667e-05 0.72 1.60111111111e-05 0.74 1.61555555556e-05 0.76 1.63e-05 0.78
+ 1.64444444444e-05 0.8 1.65888888889e-05 0.82 1.67333333333e-05 0.84 1.68777777778e-05 0.86 1.70222222222e-05 0.88 1.71666666667e-05 0.9
+ 1.73111111111e-05 0.92 1.74555555556e-05 0.94 1.76e-05 0.96 1.77444444444e-05 0.98 1.78888888889e-05 1 1.80333333333e-05 1.02
+ 1.81777777778e-05 1.04 1.83222222222e-05 1.06 1.84666666667e-05 1.08 1.86111111111e-05 1.1 1.87555555556e-05 1.12 1.89e-05 1.14
+ 1.90444444444e-05 1.16 1.91888888889e-05 1.18 1.93333333333e-05 1.2 1.94777777778e-05 1.22 1.96222222222e-05 1.24 1.97666666667e-05 1.26
+ 1.99111111111e-05 1.28 2.00555555556e-05 1.3 2.02e-05 1.32 2.03444444444e-05 1.34 2.04888888889e-05 1.36 2.06333333333e-05 1.38
+ 2.07777777778e-05 1.4 2.09222222222e-05 1.42 2.10666666667e-05 1.44 2.12111111111e-05 1.46 2.13555555556e-05 1.48 2.15e-05 1.5
+ 2.16444444444e-05 1.52 2.17888888889e-05 1.54 2.19333333333e-05 1.56 2.20777777778e-05 1.58 2.22222222222e-05 1.6 2.23666666667e-05 1.62
+ 2.25111111111e-05 1.64 2.26555555556e-05 1.66 2.28e-05 1.68 2.29444444444e-05 1.7 2.30888888889e-05 1.72 2.32333333333e-05 1.74
+ 2.33777777778e-05 1.76 2.35222222222e-05 1.78 2.36666666667e-05 1.8 2.38111111111e-05 1.82 2.39555555556e-05 1.84 2.41e-05 1.86
+ 2.42444444444e-05 1.88 2.43888888889e-05 1.9 2.45333333333e-05 1.92 2.46777777778e-05 1.94 2.48222222222e-05 1.96 2.49666666667e-05 1.98
+ 2.51111111111e-05 2 2.52555555556e-05 2.02 2.54e-05 2.04 2.55444444444e-05 2.06 2.56888888889e-05 2.08 2.58333333333e-05 2.1
+ 2.59777777778e-05 2.12 2.61222222222e-05 2.14 2.62666666667e-05 2.16 2.64111111111e-05 2.18 2.65555555556e-05 2.2 2.67e-05 2.22
+ 2.68444444444e-05 2.24 2.69888888889e-05 2.26 2.71333333333e-05 2.28 2.72777777778e-05 2.3 2.74222222222e-05 2.32 2.75666666667e-05 2.34
+ 2.77111111111e-05 2.36 2.78555555556e-05 2.38 2.8e-05 2.4 2.9e-05 0)
Vd_cv0 d_cv0 0 pwl(
+ 0 0 4e-07 0 5e-07 0.05 2.91e-05 0.05 2.92e-05 0)
Xcv0 g_cv0 d_cv0 0 0 fefet_c16 x0_1=-0.999999999 x0_2=-1 x0_3=-1 x0_4=-1 x0_5=-1 x0_6=-1
+ x0_7=-1 x0_8=-1 x0_9=-1 x0_10=-1 x0_11=-1 x0_12=-1
+ x0_13=-1 x0_14=-1 x0_15=-1 x0_16=-1
.ic v(xcv0.m)=-0.277416253
.control
set wr_singlescale
set wr_vecnames
tran 1n 3e-05 0 1.5e-07 uic
wrdata sim/out/t1e/t1e_read.csv v(g_bl0) i(vd_bl0) v(g_bl1) i(vd_bl1) v(g_bl2) i(vd_bl2) v(g_bl3) i(vd_bl3)
+ v(g_bl4) i(vd_bl4) v(g_bl5) i(vd_bl5) v(g_bh0) i(vd_bh0) v(g_bh1) i(vd_bh1)
+ v(g_bh2) i(vd_bh2) v(g_bh3) i(vd_bh3) v(g_bh4) i(vd_bh4) v(g_bh5) i(vd_bh5)
+ v(g_cl0) i(vd_cl0) v(g_cl1) i(vd_cl1) v(g_cl2) i(vd_cl2) v(g_cl3) i(vd_cl3)
+ v(g_cl4) i(vd_cl4) v(g_cl5) i(vd_cl5) v(g_ch0) i(vd_ch0) v(g_ch1) i(vd_ch1)
+ v(g_ch2) i(vd_ch2) v(g_ch3) i(vd_ch3) v(g_ch4) i(vd_ch4) v(g_ch5) i(vd_ch5)
+ v(g_cv0) i(vd_cv0)
.endc
.end
