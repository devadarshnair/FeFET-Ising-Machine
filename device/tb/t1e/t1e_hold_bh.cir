* t1e_hold_bh.cir -- generated by device/tb/make_t1e.py --stage 1
* Test 1e stage 1: hold one written FeFET for 1.1e+06 s: set B high V_th, all terminals at 0 V.
* It starts from its state 2 s after the write.
.include ../../ngspice/fefet_preisach.lib
.options reltol=1e-3 abstol=1e-15 method=gear
Vbp bp 0 pwl(0 0 100 0 1000 0 10000 0 100000 0 1000000 0 1.1e+06 0)
Rbp bp 0 1k
Xbh 0 0 0 0 fefet_b16 x0_1=0.161430918 x0_2=-0.271437025 x0_3=-0.22265841 x0_4=-0.179678028 x0_5=-0.146825874 x0_6=-0.12104344
+ x0_7=-0.0998549702 x0_8=-0.081684736 x0_9=-0.0656050025 x0_10=-0.0511330719 x0_11=-0.0380691753 x0_12=-0.0264272707
+ x0_13=-0.0163825537 x0_14=-0.00828112591 x0_15=-0.00265407502 x0_16=-0.000142689132
.ic v(xbh.m)=-0.432722171
.control
save v(xbh.xfe.x1) v(xbh.xfe.x2) v(xbh.xfe.x3) v(xbh.xfe.x4) v(xbh.xfe.x5) v(xbh.xfe.x6) v(xbh.xfe.x7) v(xbh.xfe.x8)
+ v(xbh.xfe.x9) v(xbh.xfe.x10) v(xbh.xfe.x11) v(xbh.xfe.x12) v(xbh.xfe.x13) v(xbh.xfe.x14) v(xbh.xfe.x15) v(xbh.xfe.x16)
+ v(xbh.m)
set wr_singlescale
set wr_vecnames
tran 1n 1100000 0 5500 uic
wrdata sim/out/t1e/t1e_hold_bh.csv v(xbh.xfe.x1) v(xbh.xfe.x2) v(xbh.xfe.x3) v(xbh.xfe.x4) v(xbh.xfe.x5) v(xbh.xfe.x6) v(xbh.xfe.x7) v(xbh.xfe.x8)
+ v(xbh.xfe.x9) v(xbh.xfe.x10) v(xbh.xfe.x11) v(xbh.xfe.x12) v(xbh.xfe.x13) v(xbh.xfe.x14) v(xbh.xfe.x15) v(xbh.xfe.x16)
+ v(xbh.m)
.endc
.end
