* t1f/t1f_w01.cir -- generated by device/tb/make_fefet_mw.py (width 1e-05 s)
* Test 1f: set C FeFET (W/L = 200/100 nm), memory window vs write pulse.
* Instance k = amplitude index (2.0 ... 4.4 V in 0.1 V steps). Reads: ramp -0.2 ... 2.4 V,
* V_DS = 50 mV, 2 s after each write. Checker: device/tb/check_t1f.py.
.include ../../ngspice/fefet_preisach.lib
.options reltol=1e-4 abstol=1e-15 method=gear
Vg0 g0 0 pwl(
+ 0 0 0.01009099 0 0.010090995 2 0.010100995 2 0.010101 0 2.02019099 0
+ 2.020190995 -2 2.020200995 -2 2.020201 0 4.020201 0 4.020202 -0.2 4.0202022 -0.18
+ 4.0202024 -0.16 4.0202026 -0.14 4.0202028 -0.12 4.020203 -0.1 4.0202032 -0.08 4.0202034 -0.06
+ 4.0202036 -0.04 4.0202038 -0.02 4.020204 0 4.0202042 0.02 4.0202044 0.04 4.0202046 0.06
+ 4.0202048 0.08 4.020205 0.1 4.0202052 0.12 4.0202054 0.14 4.0202056 0.16 4.0202058 0.18
+ 4.020206 0.2 4.0202062 0.22 4.0202064 0.24 4.0202066 0.26 4.0202068 0.28 4.020207 0.3
+ 4.0202072 0.32 4.0202074 0.34 4.0202076 0.36 4.0202078 0.38 4.020208 0.4 4.0202082 0.42
+ 4.0202084 0.44 4.0202086 0.46 4.0202088 0.48 4.020209 0.5 4.0202092 0.52 4.0202094 0.54
+ 4.0202096 0.56 4.0202098 0.58 4.02021 0.6 4.0202102 0.62 4.0202104 0.64 4.0202106 0.66
+ 4.0202108 0.68 4.020211 0.7 4.0202112 0.72 4.0202114 0.74 4.0202116 0.76 4.0202118 0.78
+ 4.020212 0.8 4.0202122 0.82 4.0202124 0.84 4.0202126 0.86 4.0202128 0.88 4.020213 0.9
+ 4.0202132 0.92 4.0202134 0.94 4.0202136 0.96 4.0202138 0.98 4.020214 1 4.0202142 1.02
+ 4.0202144 1.04 4.0202146 1.06 4.0202148 1.08 4.020215 1.1 4.0202152 1.12 4.0202154 1.14
+ 4.0202156 1.16 4.0202158 1.18 4.020216 1.2 4.0202162 1.22 4.0202164 1.24 4.0202166 1.26
+ 4.0202168 1.28 4.020217 1.3 4.0202172 1.32 4.0202174 1.34 4.0202176 1.36 4.0202178 1.38
+ 4.020218 1.4 4.0202182 1.42 4.0202184 1.44 4.0202186 1.46 4.0202188 1.48 4.020219 1.5
+ 4.0202192 1.52 4.0202194 1.54 4.0202196 1.56 4.0202198 1.58 4.02022 1.6 4.0202202 1.62
+ 4.0202204 1.64 4.0202206 1.66 4.0202208 1.68 4.020221 1.7 4.0202212 1.72 4.0202214 1.74
+ 4.0202216 1.76 4.0202218 1.78 4.020222 1.8 4.0202222 1.82 4.0202224 1.84 4.0202226 1.86
+ 4.0202228 1.88 4.020223 1.9 4.0202232 1.92 4.0202234 1.94 4.0202236 1.96 4.0202238 1.98
+ 4.020224 2 4.0202242 2.02 4.0202244 2.04 4.0202246 2.06 4.0202248 2.08 4.020225 2.1
+ 4.0202252 2.12 4.0202254 2.14 4.0202256 2.16 4.0202258 2.18 4.020226 2.2 4.0202262 2.22
+ 4.0202264 2.24 4.0202266 2.26 4.0202268 2.28 4.020227 2.3 4.0202272 2.32 4.0202274 2.34
+ 4.0202276 2.36 4.0202278 2.38 4.020228 2.4 4.020229 0 4.03031899 0 4.030318995 2
+ 4.030328995 2 4.030329 0 6.030329 0 6.03033 -0.2 6.0303302 -0.18 6.0303304 -0.16
+ 6.0303306 -0.14 6.0303308 -0.12 6.030331 -0.1 6.0303312 -0.08 6.0303314 -0.06 6.0303316 -0.04
+ 6.0303318 -0.02 6.030332 0 6.0303322 0.02 6.0303324 0.04 6.0303326 0.06 6.0303328 0.08
+ 6.030333 0.1 6.0303332 0.12 6.0303334 0.14 6.0303336 0.16 6.0303338 0.18 6.030334 0.2
+ 6.0303342 0.22 6.0303344 0.24 6.0303346 0.26 6.0303348 0.28 6.030335 0.3 6.0303352 0.32
+ 6.0303354 0.34 6.0303356 0.36 6.0303358 0.38 6.030336 0.4 6.0303362 0.42 6.0303364 0.44
+ 6.0303366 0.46 6.0303368 0.48 6.030337 0.5 6.0303372 0.52 6.0303374 0.54 6.0303376 0.56
+ 6.0303378 0.58 6.030338 0.6 6.0303382 0.62 6.0303384 0.64 6.0303386 0.66 6.0303388 0.68
+ 6.030339 0.7 6.0303392 0.72 6.0303394 0.74 6.0303396 0.76 6.0303398 0.78 6.03034 0.8
+ 6.0303402 0.82 6.0303404 0.84 6.0303406 0.86 6.0303408 0.88 6.030341 0.9 6.0303412 0.92
+ 6.0303414 0.94 6.0303416 0.96 6.0303418 0.98 6.030342 1 6.0303422 1.02 6.0303424 1.04
+ 6.0303426 1.06 6.0303428 1.08 6.030343 1.1 6.0303432 1.12 6.0303434 1.14 6.0303436 1.16
+ 6.0303438 1.18 6.030344 1.2 6.0303442 1.22 6.0303444 1.24 6.0303446 1.26 6.0303448 1.28
+ 6.030345 1.3 6.0303452 1.32 6.0303454 1.34 6.0303456 1.36 6.0303458 1.38 6.030346 1.4
+ 6.0303462 1.42 6.0303464 1.44 6.0303466 1.46 6.0303468 1.48 6.030347 1.5 6.0303472 1.52
+ 6.0303474 1.54 6.0303476 1.56 6.0303478 1.58 6.030348 1.6 6.0303482 1.62 6.0303484 1.64
+ 6.0303486 1.66 6.0303488 1.68 6.030349 1.7 6.0303492 1.72 6.0303494 1.74 6.0303496 1.76
+ 6.0303498 1.78 6.03035 1.8 6.0303502 1.82 6.0303504 1.84 6.0303506 1.86 6.0303508 1.88
+ 6.030351 1.9 6.0303512 1.92 6.0303514 1.94 6.0303516 1.96 6.0303518 1.98 6.030352 2
+ 6.0303522 2.02 6.0303524 2.04 6.0303526 2.06 6.0303528 2.08 6.030353 2.1 6.0303532 2.12
+ 6.0303534 2.14 6.0303536 2.16 6.0303538 2.18 6.030354 2.2 6.0303542 2.22 6.0303544 2.24
+ 6.0303546 2.26 6.0303548 2.28 6.030355 2.3 6.0303552 2.32 6.0303554 2.34 6.0303556 2.36
+ 6.0303558 2.38 6.030356 2.4 6.030357 0)
Vd0 d0 0 pwl(
+ 0 0 4.0202004 0 4.0202005 0.05 4.0202291 0.05 4.0202292 0 6.0303284 0
+ 6.0303285 0.05 6.0303571 0.05 6.0303572 0)
X0 g0 d0 0 0 fefet_c16
Vg1 g1 0 pwl(
+ 0 0 0.01009099 0 0.010090995 2.1 0.010100995 2.1 0.010101 0 2.02019099 0
+ 2.020190995 -2.1 2.020200995 -2.1 2.020201 0 4.020201 0 4.020202 -0.2 4.0202022 -0.18
+ 4.0202024 -0.16 4.0202026 -0.14 4.0202028 -0.12 4.020203 -0.1 4.0202032 -0.08 4.0202034 -0.06
+ 4.0202036 -0.04 4.0202038 -0.02 4.020204 0 4.0202042 0.02 4.0202044 0.04 4.0202046 0.06
+ 4.0202048 0.08 4.020205 0.1 4.0202052 0.12 4.0202054 0.14 4.0202056 0.16 4.0202058 0.18
+ 4.020206 0.2 4.0202062 0.22 4.0202064 0.24 4.0202066 0.26 4.0202068 0.28 4.020207 0.3
+ 4.0202072 0.32 4.0202074 0.34 4.0202076 0.36 4.0202078 0.38 4.020208 0.4 4.0202082 0.42
+ 4.0202084 0.44 4.0202086 0.46 4.0202088 0.48 4.020209 0.5 4.0202092 0.52 4.0202094 0.54
+ 4.0202096 0.56 4.0202098 0.58 4.02021 0.6 4.0202102 0.62 4.0202104 0.64 4.0202106 0.66
+ 4.0202108 0.68 4.020211 0.7 4.0202112 0.72 4.0202114 0.74 4.0202116 0.76 4.0202118 0.78
+ 4.020212 0.8 4.0202122 0.82 4.0202124 0.84 4.0202126 0.86 4.0202128 0.88 4.020213 0.9
+ 4.0202132 0.92 4.0202134 0.94 4.0202136 0.96 4.0202138 0.98 4.020214 1 4.0202142 1.02
+ 4.0202144 1.04 4.0202146 1.06 4.0202148 1.08 4.020215 1.1 4.0202152 1.12 4.0202154 1.14
+ 4.0202156 1.16 4.0202158 1.18 4.020216 1.2 4.0202162 1.22 4.0202164 1.24 4.0202166 1.26
+ 4.0202168 1.28 4.020217 1.3 4.0202172 1.32 4.0202174 1.34 4.0202176 1.36 4.0202178 1.38
+ 4.020218 1.4 4.0202182 1.42 4.0202184 1.44 4.0202186 1.46 4.0202188 1.48 4.020219 1.5
+ 4.0202192 1.52 4.0202194 1.54 4.0202196 1.56 4.0202198 1.58 4.02022 1.6 4.0202202 1.62
+ 4.0202204 1.64 4.0202206 1.66 4.0202208 1.68 4.020221 1.7 4.0202212 1.72 4.0202214 1.74
+ 4.0202216 1.76 4.0202218 1.78 4.020222 1.8 4.0202222 1.82 4.0202224 1.84 4.0202226 1.86
+ 4.0202228 1.88 4.020223 1.9 4.0202232 1.92 4.0202234 1.94 4.0202236 1.96 4.0202238 1.98
+ 4.020224 2 4.0202242 2.02 4.0202244 2.04 4.0202246 2.06 4.0202248 2.08 4.020225 2.1
+ 4.0202252 2.12 4.0202254 2.14 4.0202256 2.16 4.0202258 2.18 4.020226 2.2 4.0202262 2.22
+ 4.0202264 2.24 4.0202266 2.26 4.0202268 2.28 4.020227 2.3 4.0202272 2.32 4.0202274 2.34
+ 4.0202276 2.36 4.0202278 2.38 4.020228 2.4 4.020229 0 4.03031899 0 4.030318995 2.1
+ 4.030328995 2.1 4.030329 0 6.030329 0 6.03033 -0.2 6.0303302 -0.18 6.0303304 -0.16
+ 6.0303306 -0.14 6.0303308 -0.12 6.030331 -0.1 6.0303312 -0.08 6.0303314 -0.06 6.0303316 -0.04
+ 6.0303318 -0.02 6.030332 0 6.0303322 0.02 6.0303324 0.04 6.0303326 0.06 6.0303328 0.08
+ 6.030333 0.1 6.0303332 0.12 6.0303334 0.14 6.0303336 0.16 6.0303338 0.18 6.030334 0.2
+ 6.0303342 0.22 6.0303344 0.24 6.0303346 0.26 6.0303348 0.28 6.030335 0.3 6.0303352 0.32
+ 6.0303354 0.34 6.0303356 0.36 6.0303358 0.38 6.030336 0.4 6.0303362 0.42 6.0303364 0.44
+ 6.0303366 0.46 6.0303368 0.48 6.030337 0.5 6.0303372 0.52 6.0303374 0.54 6.0303376 0.56
+ 6.0303378 0.58 6.030338 0.6 6.0303382 0.62 6.0303384 0.64 6.0303386 0.66 6.0303388 0.68
+ 6.030339 0.7 6.0303392 0.72 6.0303394 0.74 6.0303396 0.76 6.0303398 0.78 6.03034 0.8
+ 6.0303402 0.82 6.0303404 0.84 6.0303406 0.86 6.0303408 0.88 6.030341 0.9 6.0303412 0.92
+ 6.0303414 0.94 6.0303416 0.96 6.0303418 0.98 6.030342 1 6.0303422 1.02 6.0303424 1.04
+ 6.0303426 1.06 6.0303428 1.08 6.030343 1.1 6.0303432 1.12 6.0303434 1.14 6.0303436 1.16
+ 6.0303438 1.18 6.030344 1.2 6.0303442 1.22 6.0303444 1.24 6.0303446 1.26 6.0303448 1.28
+ 6.030345 1.3 6.0303452 1.32 6.0303454 1.34 6.0303456 1.36 6.0303458 1.38 6.030346 1.4
+ 6.0303462 1.42 6.0303464 1.44 6.0303466 1.46 6.0303468 1.48 6.030347 1.5 6.0303472 1.52
+ 6.0303474 1.54 6.0303476 1.56 6.0303478 1.58 6.030348 1.6 6.0303482 1.62 6.0303484 1.64
+ 6.0303486 1.66 6.0303488 1.68 6.030349 1.7 6.0303492 1.72 6.0303494 1.74 6.0303496 1.76
+ 6.0303498 1.78 6.03035 1.8 6.0303502 1.82 6.0303504 1.84 6.0303506 1.86 6.0303508 1.88
+ 6.030351 1.9 6.0303512 1.92 6.0303514 1.94 6.0303516 1.96 6.0303518 1.98 6.030352 2
+ 6.0303522 2.02 6.0303524 2.04 6.0303526 2.06 6.0303528 2.08 6.030353 2.1 6.0303532 2.12
+ 6.0303534 2.14 6.0303536 2.16 6.0303538 2.18 6.030354 2.2 6.0303542 2.22 6.0303544 2.24
+ 6.0303546 2.26 6.0303548 2.28 6.030355 2.3 6.0303552 2.32 6.0303554 2.34 6.0303556 2.36
+ 6.0303558 2.38 6.030356 2.4 6.030357 0)
Vd1 d1 0 pwl(
+ 0 0 4.0202004 0 4.0202005 0.05 4.0202291 0.05 4.0202292 0 6.0303284 0
+ 6.0303285 0.05 6.0303571 0.05 6.0303572 0)
X1 g1 d1 0 0 fefet_c16
Vg2 g2 0 pwl(
+ 0 0 0.01009099 0 0.010090995 2.2 0.010100995 2.2 0.010101 0 2.02019099 0
+ 2.020190995 -2.2 2.020200995 -2.2 2.020201 0 4.020201 0 4.020202 -0.2 4.0202022 -0.18
+ 4.0202024 -0.16 4.0202026 -0.14 4.0202028 -0.12 4.020203 -0.1 4.0202032 -0.08 4.0202034 -0.06
+ 4.0202036 -0.04 4.0202038 -0.02 4.020204 0 4.0202042 0.02 4.0202044 0.04 4.0202046 0.06
+ 4.0202048 0.08 4.020205 0.1 4.0202052 0.12 4.0202054 0.14 4.0202056 0.16 4.0202058 0.18
+ 4.020206 0.2 4.0202062 0.22 4.0202064 0.24 4.0202066 0.26 4.0202068 0.28 4.020207 0.3
+ 4.0202072 0.32 4.0202074 0.34 4.0202076 0.36 4.0202078 0.38 4.020208 0.4 4.0202082 0.42
+ 4.0202084 0.44 4.0202086 0.46 4.0202088 0.48 4.020209 0.5 4.0202092 0.52 4.0202094 0.54
+ 4.0202096 0.56 4.0202098 0.58 4.02021 0.6 4.0202102 0.62 4.0202104 0.64 4.0202106 0.66
+ 4.0202108 0.68 4.020211 0.7 4.0202112 0.72 4.0202114 0.74 4.0202116 0.76 4.0202118 0.78
+ 4.020212 0.8 4.0202122 0.82 4.0202124 0.84 4.0202126 0.86 4.0202128 0.88 4.020213 0.9
+ 4.0202132 0.92 4.0202134 0.94 4.0202136 0.96 4.0202138 0.98 4.020214 1 4.0202142 1.02
+ 4.0202144 1.04 4.0202146 1.06 4.0202148 1.08 4.020215 1.1 4.0202152 1.12 4.0202154 1.14
+ 4.0202156 1.16 4.0202158 1.18 4.020216 1.2 4.0202162 1.22 4.0202164 1.24 4.0202166 1.26
+ 4.0202168 1.28 4.020217 1.3 4.0202172 1.32 4.0202174 1.34 4.0202176 1.36 4.0202178 1.38
+ 4.020218 1.4 4.0202182 1.42 4.0202184 1.44 4.0202186 1.46 4.0202188 1.48 4.020219 1.5
+ 4.0202192 1.52 4.0202194 1.54 4.0202196 1.56 4.0202198 1.58 4.02022 1.6 4.0202202 1.62
+ 4.0202204 1.64 4.0202206 1.66 4.0202208 1.68 4.020221 1.7 4.0202212 1.72 4.0202214 1.74
+ 4.0202216 1.76 4.0202218 1.78 4.020222 1.8 4.0202222 1.82 4.0202224 1.84 4.0202226 1.86
+ 4.0202228 1.88 4.020223 1.9 4.0202232 1.92 4.0202234 1.94 4.0202236 1.96 4.0202238 1.98
+ 4.020224 2 4.0202242 2.02 4.0202244 2.04 4.0202246 2.06 4.0202248 2.08 4.020225 2.1
+ 4.0202252 2.12 4.0202254 2.14 4.0202256 2.16 4.0202258 2.18 4.020226 2.2 4.0202262 2.22
+ 4.0202264 2.24 4.0202266 2.26 4.0202268 2.28 4.020227 2.3 4.0202272 2.32 4.0202274 2.34
+ 4.0202276 2.36 4.0202278 2.38 4.020228 2.4 4.020229 0 4.03031899 0 4.030318995 2.2
+ 4.030328995 2.2 4.030329 0 6.030329 0 6.03033 -0.2 6.0303302 -0.18 6.0303304 -0.16
+ 6.0303306 -0.14 6.0303308 -0.12 6.030331 -0.1 6.0303312 -0.08 6.0303314 -0.06 6.0303316 -0.04
+ 6.0303318 -0.02 6.030332 0 6.0303322 0.02 6.0303324 0.04 6.0303326 0.06 6.0303328 0.08
+ 6.030333 0.1 6.0303332 0.12 6.0303334 0.14 6.0303336 0.16 6.0303338 0.18 6.030334 0.2
+ 6.0303342 0.22 6.0303344 0.24 6.0303346 0.26 6.0303348 0.28 6.030335 0.3 6.0303352 0.32
+ 6.0303354 0.34 6.0303356 0.36 6.0303358 0.38 6.030336 0.4 6.0303362 0.42 6.0303364 0.44
+ 6.0303366 0.46 6.0303368 0.48 6.030337 0.5 6.0303372 0.52 6.0303374 0.54 6.0303376 0.56
+ 6.0303378 0.58 6.030338 0.6 6.0303382 0.62 6.0303384 0.64 6.0303386 0.66 6.0303388 0.68
+ 6.030339 0.7 6.0303392 0.72 6.0303394 0.74 6.0303396 0.76 6.0303398 0.78 6.03034 0.8
+ 6.0303402 0.82 6.0303404 0.84 6.0303406 0.86 6.0303408 0.88 6.030341 0.9 6.0303412 0.92
+ 6.0303414 0.94 6.0303416 0.96 6.0303418 0.98 6.030342 1 6.0303422 1.02 6.0303424 1.04
+ 6.0303426 1.06 6.0303428 1.08 6.030343 1.1 6.0303432 1.12 6.0303434 1.14 6.0303436 1.16
+ 6.0303438 1.18 6.030344 1.2 6.0303442 1.22 6.0303444 1.24 6.0303446 1.26 6.0303448 1.28
+ 6.030345 1.3 6.0303452 1.32 6.0303454 1.34 6.0303456 1.36 6.0303458 1.38 6.030346 1.4
+ 6.0303462 1.42 6.0303464 1.44 6.0303466 1.46 6.0303468 1.48 6.030347 1.5 6.0303472 1.52
+ 6.0303474 1.54 6.0303476 1.56 6.0303478 1.58 6.030348 1.6 6.0303482 1.62 6.0303484 1.64
+ 6.0303486 1.66 6.0303488 1.68 6.030349 1.7 6.0303492 1.72 6.0303494 1.74 6.0303496 1.76
+ 6.0303498 1.78 6.03035 1.8 6.0303502 1.82 6.0303504 1.84 6.0303506 1.86 6.0303508 1.88
+ 6.030351 1.9 6.0303512 1.92 6.0303514 1.94 6.0303516 1.96 6.0303518 1.98 6.030352 2
+ 6.0303522 2.02 6.0303524 2.04 6.0303526 2.06 6.0303528 2.08 6.030353 2.1 6.0303532 2.12
+ 6.0303534 2.14 6.0303536 2.16 6.0303538 2.18 6.030354 2.2 6.0303542 2.22 6.0303544 2.24
+ 6.0303546 2.26 6.0303548 2.28 6.030355 2.3 6.0303552 2.32 6.0303554 2.34 6.0303556 2.36
+ 6.0303558 2.38 6.030356 2.4 6.030357 0)
Vd2 d2 0 pwl(
+ 0 0 4.0202004 0 4.0202005 0.05 4.0202291 0.05 4.0202292 0 6.0303284 0
+ 6.0303285 0.05 6.0303571 0.05 6.0303572 0)
X2 g2 d2 0 0 fefet_c16
Vg3 g3 0 pwl(
+ 0 0 0.01009099 0 0.010090995 2.3 0.010100995 2.3 0.010101 0 2.02019099 0
+ 2.020190995 -2.3 2.020200995 -2.3 2.020201 0 4.020201 0 4.020202 -0.2 4.0202022 -0.18
+ 4.0202024 -0.16 4.0202026 -0.14 4.0202028 -0.12 4.020203 -0.1 4.0202032 -0.08 4.0202034 -0.06
+ 4.0202036 -0.04 4.0202038 -0.02 4.020204 0 4.0202042 0.02 4.0202044 0.04 4.0202046 0.06
+ 4.0202048 0.08 4.020205 0.1 4.0202052 0.12 4.0202054 0.14 4.0202056 0.16 4.0202058 0.18
+ 4.020206 0.2 4.0202062 0.22 4.0202064 0.24 4.0202066 0.26 4.0202068 0.28 4.020207 0.3
+ 4.0202072 0.32 4.0202074 0.34 4.0202076 0.36 4.0202078 0.38 4.020208 0.4 4.0202082 0.42
+ 4.0202084 0.44 4.0202086 0.46 4.0202088 0.48 4.020209 0.5 4.0202092 0.52 4.0202094 0.54
+ 4.0202096 0.56 4.0202098 0.58 4.02021 0.6 4.0202102 0.62 4.0202104 0.64 4.0202106 0.66
+ 4.0202108 0.68 4.020211 0.7 4.0202112 0.72 4.0202114 0.74 4.0202116 0.76 4.0202118 0.78
+ 4.020212 0.8 4.0202122 0.82 4.0202124 0.84 4.0202126 0.86 4.0202128 0.88 4.020213 0.9
+ 4.0202132 0.92 4.0202134 0.94 4.0202136 0.96 4.0202138 0.98 4.020214 1 4.0202142 1.02
+ 4.0202144 1.04 4.0202146 1.06 4.0202148 1.08 4.020215 1.1 4.0202152 1.12 4.0202154 1.14
+ 4.0202156 1.16 4.0202158 1.18 4.020216 1.2 4.0202162 1.22 4.0202164 1.24 4.0202166 1.26
+ 4.0202168 1.28 4.020217 1.3 4.0202172 1.32 4.0202174 1.34 4.0202176 1.36 4.0202178 1.38
+ 4.020218 1.4 4.0202182 1.42 4.0202184 1.44 4.0202186 1.46 4.0202188 1.48 4.020219 1.5
+ 4.0202192 1.52 4.0202194 1.54 4.0202196 1.56 4.0202198 1.58 4.02022 1.6 4.0202202 1.62
+ 4.0202204 1.64 4.0202206 1.66 4.0202208 1.68 4.020221 1.7 4.0202212 1.72 4.0202214 1.74
+ 4.0202216 1.76 4.0202218 1.78 4.020222 1.8 4.0202222 1.82 4.0202224 1.84 4.0202226 1.86
+ 4.0202228 1.88 4.020223 1.9 4.0202232 1.92 4.0202234 1.94 4.0202236 1.96 4.0202238 1.98
+ 4.020224 2 4.0202242 2.02 4.0202244 2.04 4.0202246 2.06 4.0202248 2.08 4.020225 2.1
+ 4.0202252 2.12 4.0202254 2.14 4.0202256 2.16 4.0202258 2.18 4.020226 2.2 4.0202262 2.22
+ 4.0202264 2.24 4.0202266 2.26 4.0202268 2.28 4.020227 2.3 4.0202272 2.32 4.0202274 2.34
+ 4.0202276 2.36 4.0202278 2.38 4.020228 2.4 4.020229 0 4.03031899 0 4.030318995 2.3
+ 4.030328995 2.3 4.030329 0 6.030329 0 6.03033 -0.2 6.0303302 -0.18 6.0303304 -0.16
+ 6.0303306 -0.14 6.0303308 -0.12 6.030331 -0.1 6.0303312 -0.08 6.0303314 -0.06 6.0303316 -0.04
+ 6.0303318 -0.02 6.030332 0 6.0303322 0.02 6.0303324 0.04 6.0303326 0.06 6.0303328 0.08
+ 6.030333 0.1 6.0303332 0.12 6.0303334 0.14 6.0303336 0.16 6.0303338 0.18 6.030334 0.2
+ 6.0303342 0.22 6.0303344 0.24 6.0303346 0.26 6.0303348 0.28 6.030335 0.3 6.0303352 0.32
+ 6.0303354 0.34 6.0303356 0.36 6.0303358 0.38 6.030336 0.4 6.0303362 0.42 6.0303364 0.44
+ 6.0303366 0.46 6.0303368 0.48 6.030337 0.5 6.0303372 0.52 6.0303374 0.54 6.0303376 0.56
+ 6.0303378 0.58 6.030338 0.6 6.0303382 0.62 6.0303384 0.64 6.0303386 0.66 6.0303388 0.68
+ 6.030339 0.7 6.0303392 0.72 6.0303394 0.74 6.0303396 0.76 6.0303398 0.78 6.03034 0.8
+ 6.0303402 0.82 6.0303404 0.84 6.0303406 0.86 6.0303408 0.88 6.030341 0.9 6.0303412 0.92
+ 6.0303414 0.94 6.0303416 0.96 6.0303418 0.98 6.030342 1 6.0303422 1.02 6.0303424 1.04
+ 6.0303426 1.06 6.0303428 1.08 6.030343 1.1 6.0303432 1.12 6.0303434 1.14 6.0303436 1.16
+ 6.0303438 1.18 6.030344 1.2 6.0303442 1.22 6.0303444 1.24 6.0303446 1.26 6.0303448 1.28
+ 6.030345 1.3 6.0303452 1.32 6.0303454 1.34 6.0303456 1.36 6.0303458 1.38 6.030346 1.4
+ 6.0303462 1.42 6.0303464 1.44 6.0303466 1.46 6.0303468 1.48 6.030347 1.5 6.0303472 1.52
+ 6.0303474 1.54 6.0303476 1.56 6.0303478 1.58 6.030348 1.6 6.0303482 1.62 6.0303484 1.64
+ 6.0303486 1.66 6.0303488 1.68 6.030349 1.7 6.0303492 1.72 6.0303494 1.74 6.0303496 1.76
+ 6.0303498 1.78 6.03035 1.8 6.0303502 1.82 6.0303504 1.84 6.0303506 1.86 6.0303508 1.88
+ 6.030351 1.9 6.0303512 1.92 6.0303514 1.94 6.0303516 1.96 6.0303518 1.98 6.030352 2
+ 6.0303522 2.02 6.0303524 2.04 6.0303526 2.06 6.0303528 2.08 6.030353 2.1 6.0303532 2.12
+ 6.0303534 2.14 6.0303536 2.16 6.0303538 2.18 6.030354 2.2 6.0303542 2.22 6.0303544 2.24
+ 6.0303546 2.26 6.0303548 2.28 6.030355 2.3 6.0303552 2.32 6.0303554 2.34 6.0303556 2.36
+ 6.0303558 2.38 6.030356 2.4 6.030357 0)
Vd3 d3 0 pwl(
+ 0 0 4.0202004 0 4.0202005 0.05 4.0202291 0.05 4.0202292 0 6.0303284 0
+ 6.0303285 0.05 6.0303571 0.05 6.0303572 0)
X3 g3 d3 0 0 fefet_c16
Vg4 g4 0 pwl(
+ 0 0 0.01009099 0 0.010090995 2.4 0.010100995 2.4 0.010101 0 2.02019099 0
+ 2.020190995 -2.4 2.020200995 -2.4 2.020201 0 4.020201 0 4.020202 -0.2 4.0202022 -0.18
+ 4.0202024 -0.16 4.0202026 -0.14 4.0202028 -0.12 4.020203 -0.1 4.0202032 -0.08 4.0202034 -0.06
+ 4.0202036 -0.04 4.0202038 -0.02 4.020204 0 4.0202042 0.02 4.0202044 0.04 4.0202046 0.06
+ 4.0202048 0.08 4.020205 0.1 4.0202052 0.12 4.0202054 0.14 4.0202056 0.16 4.0202058 0.18
+ 4.020206 0.2 4.0202062 0.22 4.0202064 0.24 4.0202066 0.26 4.0202068 0.28 4.020207 0.3
+ 4.0202072 0.32 4.0202074 0.34 4.0202076 0.36 4.0202078 0.38 4.020208 0.4 4.0202082 0.42
+ 4.0202084 0.44 4.0202086 0.46 4.0202088 0.48 4.020209 0.5 4.0202092 0.52 4.0202094 0.54
+ 4.0202096 0.56 4.0202098 0.58 4.02021 0.6 4.0202102 0.62 4.0202104 0.64 4.0202106 0.66
+ 4.0202108 0.68 4.020211 0.7 4.0202112 0.72 4.0202114 0.74 4.0202116 0.76 4.0202118 0.78
+ 4.020212 0.8 4.0202122 0.82 4.0202124 0.84 4.0202126 0.86 4.0202128 0.88 4.020213 0.9
+ 4.0202132 0.92 4.0202134 0.94 4.0202136 0.96 4.0202138 0.98 4.020214 1 4.0202142 1.02
+ 4.0202144 1.04 4.0202146 1.06 4.0202148 1.08 4.020215 1.1 4.0202152 1.12 4.0202154 1.14
+ 4.0202156 1.16 4.0202158 1.18 4.020216 1.2 4.0202162 1.22 4.0202164 1.24 4.0202166 1.26
+ 4.0202168 1.28 4.020217 1.3 4.0202172 1.32 4.0202174 1.34 4.0202176 1.36 4.0202178 1.38
+ 4.020218 1.4 4.0202182 1.42 4.0202184 1.44 4.0202186 1.46 4.0202188 1.48 4.020219 1.5
+ 4.0202192 1.52 4.0202194 1.54 4.0202196 1.56 4.0202198 1.58 4.02022 1.6 4.0202202 1.62
+ 4.0202204 1.64 4.0202206 1.66 4.0202208 1.68 4.020221 1.7 4.0202212 1.72 4.0202214 1.74
+ 4.0202216 1.76 4.0202218 1.78 4.020222 1.8 4.0202222 1.82 4.0202224 1.84 4.0202226 1.86
+ 4.0202228 1.88 4.020223 1.9 4.0202232 1.92 4.0202234 1.94 4.0202236 1.96 4.0202238 1.98
+ 4.020224 2 4.0202242 2.02 4.0202244 2.04 4.0202246 2.06 4.0202248 2.08 4.020225 2.1
+ 4.0202252 2.12 4.0202254 2.14 4.0202256 2.16 4.0202258 2.18 4.020226 2.2 4.0202262 2.22
+ 4.0202264 2.24 4.0202266 2.26 4.0202268 2.28 4.020227 2.3 4.0202272 2.32 4.0202274 2.34
+ 4.0202276 2.36 4.0202278 2.38 4.020228 2.4 4.020229 0 4.03031899 0 4.030318995 2.4
+ 4.030328995 2.4 4.030329 0 6.030329 0 6.03033 -0.2 6.0303302 -0.18 6.0303304 -0.16
+ 6.0303306 -0.14 6.0303308 -0.12 6.030331 -0.1 6.0303312 -0.08 6.0303314 -0.06 6.0303316 -0.04
+ 6.0303318 -0.02 6.030332 0 6.0303322 0.02 6.0303324 0.04 6.0303326 0.06 6.0303328 0.08
+ 6.030333 0.1 6.0303332 0.12 6.0303334 0.14 6.0303336 0.16 6.0303338 0.18 6.030334 0.2
+ 6.0303342 0.22 6.0303344 0.24 6.0303346 0.26 6.0303348 0.28 6.030335 0.3 6.0303352 0.32
+ 6.0303354 0.34 6.0303356 0.36 6.0303358 0.38 6.030336 0.4 6.0303362 0.42 6.0303364 0.44
+ 6.0303366 0.46 6.0303368 0.48 6.030337 0.5 6.0303372 0.52 6.0303374 0.54 6.0303376 0.56
+ 6.0303378 0.58 6.030338 0.6 6.0303382 0.62 6.0303384 0.64 6.0303386 0.66 6.0303388 0.68
+ 6.030339 0.7 6.0303392 0.72 6.0303394 0.74 6.0303396 0.76 6.0303398 0.78 6.03034 0.8
+ 6.0303402 0.82 6.0303404 0.84 6.0303406 0.86 6.0303408 0.88 6.030341 0.9 6.0303412 0.92
+ 6.0303414 0.94 6.0303416 0.96 6.0303418 0.98 6.030342 1 6.0303422 1.02 6.0303424 1.04
+ 6.0303426 1.06 6.0303428 1.08 6.030343 1.1 6.0303432 1.12 6.0303434 1.14 6.0303436 1.16
+ 6.0303438 1.18 6.030344 1.2 6.0303442 1.22 6.0303444 1.24 6.0303446 1.26 6.0303448 1.28
+ 6.030345 1.3 6.0303452 1.32 6.0303454 1.34 6.0303456 1.36 6.0303458 1.38 6.030346 1.4
+ 6.0303462 1.42 6.0303464 1.44 6.0303466 1.46 6.0303468 1.48 6.030347 1.5 6.0303472 1.52
+ 6.0303474 1.54 6.0303476 1.56 6.0303478 1.58 6.030348 1.6 6.0303482 1.62 6.0303484 1.64
+ 6.0303486 1.66 6.0303488 1.68 6.030349 1.7 6.0303492 1.72 6.0303494 1.74 6.0303496 1.76
+ 6.0303498 1.78 6.03035 1.8 6.0303502 1.82 6.0303504 1.84 6.0303506 1.86 6.0303508 1.88
+ 6.030351 1.9 6.0303512 1.92 6.0303514 1.94 6.0303516 1.96 6.0303518 1.98 6.030352 2
+ 6.0303522 2.02 6.0303524 2.04 6.0303526 2.06 6.0303528 2.08 6.030353 2.1 6.0303532 2.12
+ 6.0303534 2.14 6.0303536 2.16 6.0303538 2.18 6.030354 2.2 6.0303542 2.22 6.0303544 2.24
+ 6.0303546 2.26 6.0303548 2.28 6.030355 2.3 6.0303552 2.32 6.0303554 2.34 6.0303556 2.36
+ 6.0303558 2.38 6.030356 2.4 6.030357 0)
Vd4 d4 0 pwl(
+ 0 0 4.0202004 0 4.0202005 0.05 4.0202291 0.05 4.0202292 0 6.0303284 0
+ 6.0303285 0.05 6.0303571 0.05 6.0303572 0)
X4 g4 d4 0 0 fefet_c16
Vg5 g5 0 pwl(
+ 0 0 0.01009099 0 0.010090995 2.5 0.010100995 2.5 0.010101 0 2.02019099 0
+ 2.020190995 -2.5 2.020200995 -2.5 2.020201 0 4.020201 0 4.020202 -0.2 4.0202022 -0.18
+ 4.0202024 -0.16 4.0202026 -0.14 4.0202028 -0.12 4.020203 -0.1 4.0202032 -0.08 4.0202034 -0.06
+ 4.0202036 -0.04 4.0202038 -0.02 4.020204 0 4.0202042 0.02 4.0202044 0.04 4.0202046 0.06
+ 4.0202048 0.08 4.020205 0.1 4.0202052 0.12 4.0202054 0.14 4.0202056 0.16 4.0202058 0.18
+ 4.020206 0.2 4.0202062 0.22 4.0202064 0.24 4.0202066 0.26 4.0202068 0.28 4.020207 0.3
+ 4.0202072 0.32 4.0202074 0.34 4.0202076 0.36 4.0202078 0.38 4.020208 0.4 4.0202082 0.42
+ 4.0202084 0.44 4.0202086 0.46 4.0202088 0.48 4.020209 0.5 4.0202092 0.52 4.0202094 0.54
+ 4.0202096 0.56 4.0202098 0.58 4.02021 0.6 4.0202102 0.62 4.0202104 0.64 4.0202106 0.66
+ 4.0202108 0.68 4.020211 0.7 4.0202112 0.72 4.0202114 0.74 4.0202116 0.76 4.0202118 0.78
+ 4.020212 0.8 4.0202122 0.82 4.0202124 0.84 4.0202126 0.86 4.0202128 0.88 4.020213 0.9
+ 4.0202132 0.92 4.0202134 0.94 4.0202136 0.96 4.0202138 0.98 4.020214 1 4.0202142 1.02
+ 4.0202144 1.04 4.0202146 1.06 4.0202148 1.08 4.020215 1.1 4.0202152 1.12 4.0202154 1.14
+ 4.0202156 1.16 4.0202158 1.18 4.020216 1.2 4.0202162 1.22 4.0202164 1.24 4.0202166 1.26
+ 4.0202168 1.28 4.020217 1.3 4.0202172 1.32 4.0202174 1.34 4.0202176 1.36 4.0202178 1.38
+ 4.020218 1.4 4.0202182 1.42 4.0202184 1.44 4.0202186 1.46 4.0202188 1.48 4.020219 1.5
+ 4.0202192 1.52 4.0202194 1.54 4.0202196 1.56 4.0202198 1.58 4.02022 1.6 4.0202202 1.62
+ 4.0202204 1.64 4.0202206 1.66 4.0202208 1.68 4.020221 1.7 4.0202212 1.72 4.0202214 1.74
+ 4.0202216 1.76 4.0202218 1.78 4.020222 1.8 4.0202222 1.82 4.0202224 1.84 4.0202226 1.86
+ 4.0202228 1.88 4.020223 1.9 4.0202232 1.92 4.0202234 1.94 4.0202236 1.96 4.0202238 1.98
+ 4.020224 2 4.0202242 2.02 4.0202244 2.04 4.0202246 2.06 4.0202248 2.08 4.020225 2.1
+ 4.0202252 2.12 4.0202254 2.14 4.0202256 2.16 4.0202258 2.18 4.020226 2.2 4.0202262 2.22
+ 4.0202264 2.24 4.0202266 2.26 4.0202268 2.28 4.020227 2.3 4.0202272 2.32 4.0202274 2.34
+ 4.0202276 2.36 4.0202278 2.38 4.020228 2.4 4.020229 0 4.03031899 0 4.030318995 2.5
+ 4.030328995 2.5 4.030329 0 6.030329 0 6.03033 -0.2 6.0303302 -0.18 6.0303304 -0.16
+ 6.0303306 -0.14 6.0303308 -0.12 6.030331 -0.1 6.0303312 -0.08 6.0303314 -0.06 6.0303316 -0.04
+ 6.0303318 -0.02 6.030332 0 6.0303322 0.02 6.0303324 0.04 6.0303326 0.06 6.0303328 0.08
+ 6.030333 0.1 6.0303332 0.12 6.0303334 0.14 6.0303336 0.16 6.0303338 0.18 6.030334 0.2
+ 6.0303342 0.22 6.0303344 0.24 6.0303346 0.26 6.0303348 0.28 6.030335 0.3 6.0303352 0.32
+ 6.0303354 0.34 6.0303356 0.36 6.0303358 0.38 6.030336 0.4 6.0303362 0.42 6.0303364 0.44
+ 6.0303366 0.46 6.0303368 0.48 6.030337 0.5 6.0303372 0.52 6.0303374 0.54 6.0303376 0.56
+ 6.0303378 0.58 6.030338 0.6 6.0303382 0.62 6.0303384 0.64 6.0303386 0.66 6.0303388 0.68
+ 6.030339 0.7 6.0303392 0.72 6.0303394 0.74 6.0303396 0.76 6.0303398 0.78 6.03034 0.8
+ 6.0303402 0.82 6.0303404 0.84 6.0303406 0.86 6.0303408 0.88 6.030341 0.9 6.0303412 0.92
+ 6.0303414 0.94 6.0303416 0.96 6.0303418 0.98 6.030342 1 6.0303422 1.02 6.0303424 1.04
+ 6.0303426 1.06 6.0303428 1.08 6.030343 1.1 6.0303432 1.12 6.0303434 1.14 6.0303436 1.16
+ 6.0303438 1.18 6.030344 1.2 6.0303442 1.22 6.0303444 1.24 6.0303446 1.26 6.0303448 1.28
+ 6.030345 1.3 6.0303452 1.32 6.0303454 1.34 6.0303456 1.36 6.0303458 1.38 6.030346 1.4
+ 6.0303462 1.42 6.0303464 1.44 6.0303466 1.46 6.0303468 1.48 6.030347 1.5 6.0303472 1.52
+ 6.0303474 1.54 6.0303476 1.56 6.0303478 1.58 6.030348 1.6 6.0303482 1.62 6.0303484 1.64
+ 6.0303486 1.66 6.0303488 1.68 6.030349 1.7 6.0303492 1.72 6.0303494 1.74 6.0303496 1.76
+ 6.0303498 1.78 6.03035 1.8 6.0303502 1.82 6.0303504 1.84 6.0303506 1.86 6.0303508 1.88
+ 6.030351 1.9 6.0303512 1.92 6.0303514 1.94 6.0303516 1.96 6.0303518 1.98 6.030352 2
+ 6.0303522 2.02 6.0303524 2.04 6.0303526 2.06 6.0303528 2.08 6.030353 2.1 6.0303532 2.12
+ 6.0303534 2.14 6.0303536 2.16 6.0303538 2.18 6.030354 2.2 6.0303542 2.22 6.0303544 2.24
+ 6.0303546 2.26 6.0303548 2.28 6.030355 2.3 6.0303552 2.32 6.0303554 2.34 6.0303556 2.36
+ 6.0303558 2.38 6.030356 2.4 6.030357 0)
Vd5 d5 0 pwl(
+ 0 0 4.0202004 0 4.0202005 0.05 4.0202291 0.05 4.0202292 0 6.0303284 0
+ 6.0303285 0.05 6.0303571 0.05 6.0303572 0)
X5 g5 d5 0 0 fefet_c16
Vg6 g6 0 pwl(
+ 0 0 0.01009099 0 0.010090995 2.6 0.010100995 2.6 0.010101 0 2.02019099 0
+ 2.020190995 -2.6 2.020200995 -2.6 2.020201 0 4.020201 0 4.020202 -0.2 4.0202022 -0.18
+ 4.0202024 -0.16 4.0202026 -0.14 4.0202028 -0.12 4.020203 -0.1 4.0202032 -0.08 4.0202034 -0.06
+ 4.0202036 -0.04 4.0202038 -0.02 4.020204 0 4.0202042 0.02 4.0202044 0.04 4.0202046 0.06
+ 4.0202048 0.08 4.020205 0.1 4.0202052 0.12 4.0202054 0.14 4.0202056 0.16 4.0202058 0.18
+ 4.020206 0.2 4.0202062 0.22 4.0202064 0.24 4.0202066 0.26 4.0202068 0.28 4.020207 0.3
+ 4.0202072 0.32 4.0202074 0.34 4.0202076 0.36 4.0202078 0.38 4.020208 0.4 4.0202082 0.42
+ 4.0202084 0.44 4.0202086 0.46 4.0202088 0.48 4.020209 0.5 4.0202092 0.52 4.0202094 0.54
+ 4.0202096 0.56 4.0202098 0.58 4.02021 0.6 4.0202102 0.62 4.0202104 0.64 4.0202106 0.66
+ 4.0202108 0.68 4.020211 0.7 4.0202112 0.72 4.0202114 0.74 4.0202116 0.76 4.0202118 0.78
+ 4.020212 0.8 4.0202122 0.82 4.0202124 0.84 4.0202126 0.86 4.0202128 0.88 4.020213 0.9
+ 4.0202132 0.92 4.0202134 0.94 4.0202136 0.96 4.0202138 0.98 4.020214 1 4.0202142 1.02
+ 4.0202144 1.04 4.0202146 1.06 4.0202148 1.08 4.020215 1.1 4.0202152 1.12 4.0202154 1.14
+ 4.0202156 1.16 4.0202158 1.18 4.020216 1.2 4.0202162 1.22 4.0202164 1.24 4.0202166 1.26
+ 4.0202168 1.28 4.020217 1.3 4.0202172 1.32 4.0202174 1.34 4.0202176 1.36 4.0202178 1.38
+ 4.020218 1.4 4.0202182 1.42 4.0202184 1.44 4.0202186 1.46 4.0202188 1.48 4.020219 1.5
+ 4.0202192 1.52 4.0202194 1.54 4.0202196 1.56 4.0202198 1.58 4.02022 1.6 4.0202202 1.62
+ 4.0202204 1.64 4.0202206 1.66 4.0202208 1.68 4.020221 1.7 4.0202212 1.72 4.0202214 1.74
+ 4.0202216 1.76 4.0202218 1.78 4.020222 1.8 4.0202222 1.82 4.0202224 1.84 4.0202226 1.86
+ 4.0202228 1.88 4.020223 1.9 4.0202232 1.92 4.0202234 1.94 4.0202236 1.96 4.0202238 1.98
+ 4.020224 2 4.0202242 2.02 4.0202244 2.04 4.0202246 2.06 4.0202248 2.08 4.020225 2.1
+ 4.0202252 2.12 4.0202254 2.14 4.0202256 2.16 4.0202258 2.18 4.020226 2.2 4.0202262 2.22
+ 4.0202264 2.24 4.0202266 2.26 4.0202268 2.28 4.020227 2.3 4.0202272 2.32 4.0202274 2.34
+ 4.0202276 2.36 4.0202278 2.38 4.020228 2.4 4.020229 0 4.03031899 0 4.030318995 2.6
+ 4.030328995 2.6 4.030329 0 6.030329 0 6.03033 -0.2 6.0303302 -0.18 6.0303304 -0.16
+ 6.0303306 -0.14 6.0303308 -0.12 6.030331 -0.1 6.0303312 -0.08 6.0303314 -0.06 6.0303316 -0.04
+ 6.0303318 -0.02 6.030332 0 6.0303322 0.02 6.0303324 0.04 6.0303326 0.06 6.0303328 0.08
+ 6.030333 0.1 6.0303332 0.12 6.0303334 0.14 6.0303336 0.16 6.0303338 0.18 6.030334 0.2
+ 6.0303342 0.22 6.0303344 0.24 6.0303346 0.26 6.0303348 0.28 6.030335 0.3 6.0303352 0.32
+ 6.0303354 0.34 6.0303356 0.36 6.0303358 0.38 6.030336 0.4 6.0303362 0.42 6.0303364 0.44
+ 6.0303366 0.46 6.0303368 0.48 6.030337 0.5 6.0303372 0.52 6.0303374 0.54 6.0303376 0.56
+ 6.0303378 0.58 6.030338 0.6 6.0303382 0.62 6.0303384 0.64 6.0303386 0.66 6.0303388 0.68
+ 6.030339 0.7 6.0303392 0.72 6.0303394 0.74 6.0303396 0.76 6.0303398 0.78 6.03034 0.8
+ 6.0303402 0.82 6.0303404 0.84 6.0303406 0.86 6.0303408 0.88 6.030341 0.9 6.0303412 0.92
+ 6.0303414 0.94 6.0303416 0.96 6.0303418 0.98 6.030342 1 6.0303422 1.02 6.0303424 1.04
+ 6.0303426 1.06 6.0303428 1.08 6.030343 1.1 6.0303432 1.12 6.0303434 1.14 6.0303436 1.16
+ 6.0303438 1.18 6.030344 1.2 6.0303442 1.22 6.0303444 1.24 6.0303446 1.26 6.0303448 1.28
+ 6.030345 1.3 6.0303452 1.32 6.0303454 1.34 6.0303456 1.36 6.0303458 1.38 6.030346 1.4
+ 6.0303462 1.42 6.0303464 1.44 6.0303466 1.46 6.0303468 1.48 6.030347 1.5 6.0303472 1.52
+ 6.0303474 1.54 6.0303476 1.56 6.0303478 1.58 6.030348 1.6 6.0303482 1.62 6.0303484 1.64
+ 6.0303486 1.66 6.0303488 1.68 6.030349 1.7 6.0303492 1.72 6.0303494 1.74 6.0303496 1.76
+ 6.0303498 1.78 6.03035 1.8 6.0303502 1.82 6.0303504 1.84 6.0303506 1.86 6.0303508 1.88
+ 6.030351 1.9 6.0303512 1.92 6.0303514 1.94 6.0303516 1.96 6.0303518 1.98 6.030352 2
+ 6.0303522 2.02 6.0303524 2.04 6.0303526 2.06 6.0303528 2.08 6.030353 2.1 6.0303532 2.12
+ 6.0303534 2.14 6.0303536 2.16 6.0303538 2.18 6.030354 2.2 6.0303542 2.22 6.0303544 2.24
+ 6.0303546 2.26 6.0303548 2.28 6.030355 2.3 6.0303552 2.32 6.0303554 2.34 6.0303556 2.36
+ 6.0303558 2.38 6.030356 2.4 6.030357 0)
Vd6 d6 0 pwl(
+ 0 0 4.0202004 0 4.0202005 0.05 4.0202291 0.05 4.0202292 0 6.0303284 0
+ 6.0303285 0.05 6.0303571 0.05 6.0303572 0)
X6 g6 d6 0 0 fefet_c16
Vg7 g7 0 pwl(
+ 0 0 0.01009099 0 0.010090995 2.7 0.010100995 2.7 0.010101 0 2.02019099 0
+ 2.020190995 -2.7 2.020200995 -2.7 2.020201 0 4.020201 0 4.020202 -0.2 4.0202022 -0.18
+ 4.0202024 -0.16 4.0202026 -0.14 4.0202028 -0.12 4.020203 -0.1 4.0202032 -0.08 4.0202034 -0.06
+ 4.0202036 -0.04 4.0202038 -0.02 4.020204 0 4.0202042 0.02 4.0202044 0.04 4.0202046 0.06
+ 4.0202048 0.08 4.020205 0.1 4.0202052 0.12 4.0202054 0.14 4.0202056 0.16 4.0202058 0.18
+ 4.020206 0.2 4.0202062 0.22 4.0202064 0.24 4.0202066 0.26 4.0202068 0.28 4.020207 0.3
+ 4.0202072 0.32 4.0202074 0.34 4.0202076 0.36 4.0202078 0.38 4.020208 0.4 4.0202082 0.42
+ 4.0202084 0.44 4.0202086 0.46 4.0202088 0.48 4.020209 0.5 4.0202092 0.52 4.0202094 0.54
+ 4.0202096 0.56 4.0202098 0.58 4.02021 0.6 4.0202102 0.62 4.0202104 0.64 4.0202106 0.66
+ 4.0202108 0.68 4.020211 0.7 4.0202112 0.72 4.0202114 0.74 4.0202116 0.76 4.0202118 0.78
+ 4.020212 0.8 4.0202122 0.82 4.0202124 0.84 4.0202126 0.86 4.0202128 0.88 4.020213 0.9
+ 4.0202132 0.92 4.0202134 0.94 4.0202136 0.96 4.0202138 0.98 4.020214 1 4.0202142 1.02
+ 4.0202144 1.04 4.0202146 1.06 4.0202148 1.08 4.020215 1.1 4.0202152 1.12 4.0202154 1.14
+ 4.0202156 1.16 4.0202158 1.18 4.020216 1.2 4.0202162 1.22 4.0202164 1.24 4.0202166 1.26
+ 4.0202168 1.28 4.020217 1.3 4.0202172 1.32 4.0202174 1.34 4.0202176 1.36 4.0202178 1.38
+ 4.020218 1.4 4.0202182 1.42 4.0202184 1.44 4.0202186 1.46 4.0202188 1.48 4.020219 1.5
+ 4.0202192 1.52 4.0202194 1.54 4.0202196 1.56 4.0202198 1.58 4.02022 1.6 4.0202202 1.62
+ 4.0202204 1.64 4.0202206 1.66 4.0202208 1.68 4.020221 1.7 4.0202212 1.72 4.0202214 1.74
+ 4.0202216 1.76 4.0202218 1.78 4.020222 1.8 4.0202222 1.82 4.0202224 1.84 4.0202226 1.86
+ 4.0202228 1.88 4.020223 1.9 4.0202232 1.92 4.0202234 1.94 4.0202236 1.96 4.0202238 1.98
+ 4.020224 2 4.0202242 2.02 4.0202244 2.04 4.0202246 2.06 4.0202248 2.08 4.020225 2.1
+ 4.0202252 2.12 4.0202254 2.14 4.0202256 2.16 4.0202258 2.18 4.020226 2.2 4.0202262 2.22
+ 4.0202264 2.24 4.0202266 2.26 4.0202268 2.28 4.020227 2.3 4.0202272 2.32 4.0202274 2.34
+ 4.0202276 2.36 4.0202278 2.38 4.020228 2.4 4.020229 0 4.03031899 0 4.030318995 2.7
+ 4.030328995 2.7 4.030329 0 6.030329 0 6.03033 -0.2 6.0303302 -0.18 6.0303304 -0.16
+ 6.0303306 -0.14 6.0303308 -0.12 6.030331 -0.1 6.0303312 -0.08 6.0303314 -0.06 6.0303316 -0.04
+ 6.0303318 -0.02 6.030332 0 6.0303322 0.02 6.0303324 0.04 6.0303326 0.06 6.0303328 0.08
+ 6.030333 0.1 6.0303332 0.12 6.0303334 0.14 6.0303336 0.16 6.0303338 0.18 6.030334 0.2
+ 6.0303342 0.22 6.0303344 0.24 6.0303346 0.26 6.0303348 0.28 6.030335 0.3 6.0303352 0.32
+ 6.0303354 0.34 6.0303356 0.36 6.0303358 0.38 6.030336 0.4 6.0303362 0.42 6.0303364 0.44
+ 6.0303366 0.46 6.0303368 0.48 6.030337 0.5 6.0303372 0.52 6.0303374 0.54 6.0303376 0.56
+ 6.0303378 0.58 6.030338 0.6 6.0303382 0.62 6.0303384 0.64 6.0303386 0.66 6.0303388 0.68
+ 6.030339 0.7 6.0303392 0.72 6.0303394 0.74 6.0303396 0.76 6.0303398 0.78 6.03034 0.8
+ 6.0303402 0.82 6.0303404 0.84 6.0303406 0.86 6.0303408 0.88 6.030341 0.9 6.0303412 0.92
+ 6.0303414 0.94 6.0303416 0.96 6.0303418 0.98 6.030342 1 6.0303422 1.02 6.0303424 1.04
+ 6.0303426 1.06 6.0303428 1.08 6.030343 1.1 6.0303432 1.12 6.0303434 1.14 6.0303436 1.16
+ 6.0303438 1.18 6.030344 1.2 6.0303442 1.22 6.0303444 1.24 6.0303446 1.26 6.0303448 1.28
+ 6.030345 1.3 6.0303452 1.32 6.0303454 1.34 6.0303456 1.36 6.0303458 1.38 6.030346 1.4
+ 6.0303462 1.42 6.0303464 1.44 6.0303466 1.46 6.0303468 1.48 6.030347 1.5 6.0303472 1.52
+ 6.0303474 1.54 6.0303476 1.56 6.0303478 1.58 6.030348 1.6 6.0303482 1.62 6.0303484 1.64
+ 6.0303486 1.66 6.0303488 1.68 6.030349 1.7 6.0303492 1.72 6.0303494 1.74 6.0303496 1.76
+ 6.0303498 1.78 6.03035 1.8 6.0303502 1.82 6.0303504 1.84 6.0303506 1.86 6.0303508 1.88
+ 6.030351 1.9 6.0303512 1.92 6.0303514 1.94 6.0303516 1.96 6.0303518 1.98 6.030352 2
+ 6.0303522 2.02 6.0303524 2.04 6.0303526 2.06 6.0303528 2.08 6.030353 2.1 6.0303532 2.12
+ 6.0303534 2.14 6.0303536 2.16 6.0303538 2.18 6.030354 2.2 6.0303542 2.22 6.0303544 2.24
+ 6.0303546 2.26 6.0303548 2.28 6.030355 2.3 6.0303552 2.32 6.0303554 2.34 6.0303556 2.36
+ 6.0303558 2.38 6.030356 2.4 6.030357 0)
Vd7 d7 0 pwl(
+ 0 0 4.0202004 0 4.0202005 0.05 4.0202291 0.05 4.0202292 0 6.0303284 0
+ 6.0303285 0.05 6.0303571 0.05 6.0303572 0)
X7 g7 d7 0 0 fefet_c16
Vg8 g8 0 pwl(
+ 0 0 0.01009099 0 0.010090995 2.8 0.010100995 2.8 0.010101 0 2.02019099 0
+ 2.020190995 -2.8 2.020200995 -2.8 2.020201 0 4.020201 0 4.020202 -0.2 4.0202022 -0.18
+ 4.0202024 -0.16 4.0202026 -0.14 4.0202028 -0.12 4.020203 -0.1 4.0202032 -0.08 4.0202034 -0.06
+ 4.0202036 -0.04 4.0202038 -0.02 4.020204 0 4.0202042 0.02 4.0202044 0.04 4.0202046 0.06
+ 4.0202048 0.08 4.020205 0.1 4.0202052 0.12 4.0202054 0.14 4.0202056 0.16 4.0202058 0.18
+ 4.020206 0.2 4.0202062 0.22 4.0202064 0.24 4.0202066 0.26 4.0202068 0.28 4.020207 0.3
+ 4.0202072 0.32 4.0202074 0.34 4.0202076 0.36 4.0202078 0.38 4.020208 0.4 4.0202082 0.42
+ 4.0202084 0.44 4.0202086 0.46 4.0202088 0.48 4.020209 0.5 4.0202092 0.52 4.0202094 0.54
+ 4.0202096 0.56 4.0202098 0.58 4.02021 0.6 4.0202102 0.62 4.0202104 0.64 4.0202106 0.66
+ 4.0202108 0.68 4.020211 0.7 4.0202112 0.72 4.0202114 0.74 4.0202116 0.76 4.0202118 0.78
+ 4.020212 0.8 4.0202122 0.82 4.0202124 0.84 4.0202126 0.86 4.0202128 0.88 4.020213 0.9
+ 4.0202132 0.92 4.0202134 0.94 4.0202136 0.96 4.0202138 0.98 4.020214 1 4.0202142 1.02
+ 4.0202144 1.04 4.0202146 1.06 4.0202148 1.08 4.020215 1.1 4.0202152 1.12 4.0202154 1.14
+ 4.0202156 1.16 4.0202158 1.18 4.020216 1.2 4.0202162 1.22 4.0202164 1.24 4.0202166 1.26
+ 4.0202168 1.28 4.020217 1.3 4.0202172 1.32 4.0202174 1.34 4.0202176 1.36 4.0202178 1.38
+ 4.020218 1.4 4.0202182 1.42 4.0202184 1.44 4.0202186 1.46 4.0202188 1.48 4.020219 1.5
+ 4.0202192 1.52 4.0202194 1.54 4.0202196 1.56 4.0202198 1.58 4.02022 1.6 4.0202202 1.62
+ 4.0202204 1.64 4.0202206 1.66 4.0202208 1.68 4.020221 1.7 4.0202212 1.72 4.0202214 1.74
+ 4.0202216 1.76 4.0202218 1.78 4.020222 1.8 4.0202222 1.82 4.0202224 1.84 4.0202226 1.86
+ 4.0202228 1.88 4.020223 1.9 4.0202232 1.92 4.0202234 1.94 4.0202236 1.96 4.0202238 1.98
+ 4.020224 2 4.0202242 2.02 4.0202244 2.04 4.0202246 2.06 4.0202248 2.08 4.020225 2.1
+ 4.0202252 2.12 4.0202254 2.14 4.0202256 2.16 4.0202258 2.18 4.020226 2.2 4.0202262 2.22
+ 4.0202264 2.24 4.0202266 2.26 4.0202268 2.28 4.020227 2.3 4.0202272 2.32 4.0202274 2.34
+ 4.0202276 2.36 4.0202278 2.38 4.020228 2.4 4.020229 0 4.03031899 0 4.030318995 2.8
+ 4.030328995 2.8 4.030329 0 6.030329 0 6.03033 -0.2 6.0303302 -0.18 6.0303304 -0.16
+ 6.0303306 -0.14 6.0303308 -0.12 6.030331 -0.1 6.0303312 -0.08 6.0303314 -0.06 6.0303316 -0.04
+ 6.0303318 -0.02 6.030332 0 6.0303322 0.02 6.0303324 0.04 6.0303326 0.06 6.0303328 0.08
+ 6.030333 0.1 6.0303332 0.12 6.0303334 0.14 6.0303336 0.16 6.0303338 0.18 6.030334 0.2
+ 6.0303342 0.22 6.0303344 0.24 6.0303346 0.26 6.0303348 0.28 6.030335 0.3 6.0303352 0.32
+ 6.0303354 0.34 6.0303356 0.36 6.0303358 0.38 6.030336 0.4 6.0303362 0.42 6.0303364 0.44
+ 6.0303366 0.46 6.0303368 0.48 6.030337 0.5 6.0303372 0.52 6.0303374 0.54 6.0303376 0.56
+ 6.0303378 0.58 6.030338 0.6 6.0303382 0.62 6.0303384 0.64 6.0303386 0.66 6.0303388 0.68
+ 6.030339 0.7 6.0303392 0.72 6.0303394 0.74 6.0303396 0.76 6.0303398 0.78 6.03034 0.8
+ 6.0303402 0.82 6.0303404 0.84 6.0303406 0.86 6.0303408 0.88 6.030341 0.9 6.0303412 0.92
+ 6.0303414 0.94 6.0303416 0.96 6.0303418 0.98 6.030342 1 6.0303422 1.02 6.0303424 1.04
+ 6.0303426 1.06 6.0303428 1.08 6.030343 1.1 6.0303432 1.12 6.0303434 1.14 6.0303436 1.16
+ 6.0303438 1.18 6.030344 1.2 6.0303442 1.22 6.0303444 1.24 6.0303446 1.26 6.0303448 1.28
+ 6.030345 1.3 6.0303452 1.32 6.0303454 1.34 6.0303456 1.36 6.0303458 1.38 6.030346 1.4
+ 6.0303462 1.42 6.0303464 1.44 6.0303466 1.46 6.0303468 1.48 6.030347 1.5 6.0303472 1.52
+ 6.0303474 1.54 6.0303476 1.56 6.0303478 1.58 6.030348 1.6 6.0303482 1.62 6.0303484 1.64
+ 6.0303486 1.66 6.0303488 1.68 6.030349 1.7 6.0303492 1.72 6.0303494 1.74 6.0303496 1.76
+ 6.0303498 1.78 6.03035 1.8 6.0303502 1.82 6.0303504 1.84 6.0303506 1.86 6.0303508 1.88
+ 6.030351 1.9 6.0303512 1.92 6.0303514 1.94 6.0303516 1.96 6.0303518 1.98 6.030352 2
+ 6.0303522 2.02 6.0303524 2.04 6.0303526 2.06 6.0303528 2.08 6.030353 2.1 6.0303532 2.12
+ 6.0303534 2.14 6.0303536 2.16 6.0303538 2.18 6.030354 2.2 6.0303542 2.22 6.0303544 2.24
+ 6.0303546 2.26 6.0303548 2.28 6.030355 2.3 6.0303552 2.32 6.0303554 2.34 6.0303556 2.36
+ 6.0303558 2.38 6.030356 2.4 6.030357 0)
Vd8 d8 0 pwl(
+ 0 0 4.0202004 0 4.0202005 0.05 4.0202291 0.05 4.0202292 0 6.0303284 0
+ 6.0303285 0.05 6.0303571 0.05 6.0303572 0)
X8 g8 d8 0 0 fefet_c16
Vg9 g9 0 pwl(
+ 0 0 0.01009099 0 0.010090995 2.9 0.010100995 2.9 0.010101 0 2.02019099 0
+ 2.020190995 -2.9 2.020200995 -2.9 2.020201 0 4.020201 0 4.020202 -0.2 4.0202022 -0.18
+ 4.0202024 -0.16 4.0202026 -0.14 4.0202028 -0.12 4.020203 -0.1 4.0202032 -0.08 4.0202034 -0.06
+ 4.0202036 -0.04 4.0202038 -0.02 4.020204 0 4.0202042 0.02 4.0202044 0.04 4.0202046 0.06
+ 4.0202048 0.08 4.020205 0.1 4.0202052 0.12 4.0202054 0.14 4.0202056 0.16 4.0202058 0.18
+ 4.020206 0.2 4.0202062 0.22 4.0202064 0.24 4.0202066 0.26 4.0202068 0.28 4.020207 0.3
+ 4.0202072 0.32 4.0202074 0.34 4.0202076 0.36 4.0202078 0.38 4.020208 0.4 4.0202082 0.42
+ 4.0202084 0.44 4.0202086 0.46 4.0202088 0.48 4.020209 0.5 4.0202092 0.52 4.0202094 0.54
+ 4.0202096 0.56 4.0202098 0.58 4.02021 0.6 4.0202102 0.62 4.0202104 0.64 4.0202106 0.66
+ 4.0202108 0.68 4.020211 0.7 4.0202112 0.72 4.0202114 0.74 4.0202116 0.76 4.0202118 0.78
+ 4.020212 0.8 4.0202122 0.82 4.0202124 0.84 4.0202126 0.86 4.0202128 0.88 4.020213 0.9
+ 4.0202132 0.92 4.0202134 0.94 4.0202136 0.96 4.0202138 0.98 4.020214 1 4.0202142 1.02
+ 4.0202144 1.04 4.0202146 1.06 4.0202148 1.08 4.020215 1.1 4.0202152 1.12 4.0202154 1.14
+ 4.0202156 1.16 4.0202158 1.18 4.020216 1.2 4.0202162 1.22 4.0202164 1.24 4.0202166 1.26
+ 4.0202168 1.28 4.020217 1.3 4.0202172 1.32 4.0202174 1.34 4.0202176 1.36 4.0202178 1.38
+ 4.020218 1.4 4.0202182 1.42 4.0202184 1.44 4.0202186 1.46 4.0202188 1.48 4.020219 1.5
+ 4.0202192 1.52 4.0202194 1.54 4.0202196 1.56 4.0202198 1.58 4.02022 1.6 4.0202202 1.62
+ 4.0202204 1.64 4.0202206 1.66 4.0202208 1.68 4.020221 1.7 4.0202212 1.72 4.0202214 1.74
+ 4.0202216 1.76 4.0202218 1.78 4.020222 1.8 4.0202222 1.82 4.0202224 1.84 4.0202226 1.86
+ 4.0202228 1.88 4.020223 1.9 4.0202232 1.92 4.0202234 1.94 4.0202236 1.96 4.0202238 1.98
+ 4.020224 2 4.0202242 2.02 4.0202244 2.04 4.0202246 2.06 4.0202248 2.08 4.020225 2.1
+ 4.0202252 2.12 4.0202254 2.14 4.0202256 2.16 4.0202258 2.18 4.020226 2.2 4.0202262 2.22
+ 4.0202264 2.24 4.0202266 2.26 4.0202268 2.28 4.020227 2.3 4.0202272 2.32 4.0202274 2.34
+ 4.0202276 2.36 4.0202278 2.38 4.020228 2.4 4.020229 0 4.03031899 0 4.030318995 2.9
+ 4.030328995 2.9 4.030329 0 6.030329 0 6.03033 -0.2 6.0303302 -0.18 6.0303304 -0.16
+ 6.0303306 -0.14 6.0303308 -0.12 6.030331 -0.1 6.0303312 -0.08 6.0303314 -0.06 6.0303316 -0.04
+ 6.0303318 -0.02 6.030332 0 6.0303322 0.02 6.0303324 0.04 6.0303326 0.06 6.0303328 0.08
+ 6.030333 0.1 6.0303332 0.12 6.0303334 0.14 6.0303336 0.16 6.0303338 0.18 6.030334 0.2
+ 6.0303342 0.22 6.0303344 0.24 6.0303346 0.26 6.0303348 0.28 6.030335 0.3 6.0303352 0.32
+ 6.0303354 0.34 6.0303356 0.36 6.0303358 0.38 6.030336 0.4 6.0303362 0.42 6.0303364 0.44
+ 6.0303366 0.46 6.0303368 0.48 6.030337 0.5 6.0303372 0.52 6.0303374 0.54 6.0303376 0.56
+ 6.0303378 0.58 6.030338 0.6 6.0303382 0.62 6.0303384 0.64 6.0303386 0.66 6.0303388 0.68
+ 6.030339 0.7 6.0303392 0.72 6.0303394 0.74 6.0303396 0.76 6.0303398 0.78 6.03034 0.8
+ 6.0303402 0.82 6.0303404 0.84 6.0303406 0.86 6.0303408 0.88 6.030341 0.9 6.0303412 0.92
+ 6.0303414 0.94 6.0303416 0.96 6.0303418 0.98 6.030342 1 6.0303422 1.02 6.0303424 1.04
+ 6.0303426 1.06 6.0303428 1.08 6.030343 1.1 6.0303432 1.12 6.0303434 1.14 6.0303436 1.16
+ 6.0303438 1.18 6.030344 1.2 6.0303442 1.22 6.0303444 1.24 6.0303446 1.26 6.0303448 1.28
+ 6.030345 1.3 6.0303452 1.32 6.0303454 1.34 6.0303456 1.36 6.0303458 1.38 6.030346 1.4
+ 6.0303462 1.42 6.0303464 1.44 6.0303466 1.46 6.0303468 1.48 6.030347 1.5 6.0303472 1.52
+ 6.0303474 1.54 6.0303476 1.56 6.0303478 1.58 6.030348 1.6 6.0303482 1.62 6.0303484 1.64
+ 6.0303486 1.66 6.0303488 1.68 6.030349 1.7 6.0303492 1.72 6.0303494 1.74 6.0303496 1.76
+ 6.0303498 1.78 6.03035 1.8 6.0303502 1.82 6.0303504 1.84 6.0303506 1.86 6.0303508 1.88
+ 6.030351 1.9 6.0303512 1.92 6.0303514 1.94 6.0303516 1.96 6.0303518 1.98 6.030352 2
+ 6.0303522 2.02 6.0303524 2.04 6.0303526 2.06 6.0303528 2.08 6.030353 2.1 6.0303532 2.12
+ 6.0303534 2.14 6.0303536 2.16 6.0303538 2.18 6.030354 2.2 6.0303542 2.22 6.0303544 2.24
+ 6.0303546 2.26 6.0303548 2.28 6.030355 2.3 6.0303552 2.32 6.0303554 2.34 6.0303556 2.36
+ 6.0303558 2.38 6.030356 2.4 6.030357 0)
Vd9 d9 0 pwl(
+ 0 0 4.0202004 0 4.0202005 0.05 4.0202291 0.05 4.0202292 0 6.0303284 0
+ 6.0303285 0.05 6.0303571 0.05 6.0303572 0)
X9 g9 d9 0 0 fefet_c16
Vg10 g10 0 pwl(
+ 0 0 0.01009099 0 0.010090995 3 0.010100995 3 0.010101 0 2.02019099 0
+ 2.020190995 -3 2.020200995 -3 2.020201 0 4.020201 0 4.020202 -0.2 4.0202022 -0.18
+ 4.0202024 -0.16 4.0202026 -0.14 4.0202028 -0.12 4.020203 -0.1 4.0202032 -0.08 4.0202034 -0.06
+ 4.0202036 -0.04 4.0202038 -0.02 4.020204 0 4.0202042 0.02 4.0202044 0.04 4.0202046 0.06
+ 4.0202048 0.08 4.020205 0.1 4.0202052 0.12 4.0202054 0.14 4.0202056 0.16 4.0202058 0.18
+ 4.020206 0.2 4.0202062 0.22 4.0202064 0.24 4.0202066 0.26 4.0202068 0.28 4.020207 0.3
+ 4.0202072 0.32 4.0202074 0.34 4.0202076 0.36 4.0202078 0.38 4.020208 0.4 4.0202082 0.42
+ 4.0202084 0.44 4.0202086 0.46 4.0202088 0.48 4.020209 0.5 4.0202092 0.52 4.0202094 0.54
+ 4.0202096 0.56 4.0202098 0.58 4.02021 0.6 4.0202102 0.62 4.0202104 0.64 4.0202106 0.66
+ 4.0202108 0.68 4.020211 0.7 4.0202112 0.72 4.0202114 0.74 4.0202116 0.76 4.0202118 0.78
+ 4.020212 0.8 4.0202122 0.82 4.0202124 0.84 4.0202126 0.86 4.0202128 0.88 4.020213 0.9
+ 4.0202132 0.92 4.0202134 0.94 4.0202136 0.96 4.0202138 0.98 4.020214 1 4.0202142 1.02
+ 4.0202144 1.04 4.0202146 1.06 4.0202148 1.08 4.020215 1.1 4.0202152 1.12 4.0202154 1.14
+ 4.0202156 1.16 4.0202158 1.18 4.020216 1.2 4.0202162 1.22 4.0202164 1.24 4.0202166 1.26
+ 4.0202168 1.28 4.020217 1.3 4.0202172 1.32 4.0202174 1.34 4.0202176 1.36 4.0202178 1.38
+ 4.020218 1.4 4.0202182 1.42 4.0202184 1.44 4.0202186 1.46 4.0202188 1.48 4.020219 1.5
+ 4.0202192 1.52 4.0202194 1.54 4.0202196 1.56 4.0202198 1.58 4.02022 1.6 4.0202202 1.62
+ 4.0202204 1.64 4.0202206 1.66 4.0202208 1.68 4.020221 1.7 4.0202212 1.72 4.0202214 1.74
+ 4.0202216 1.76 4.0202218 1.78 4.020222 1.8 4.0202222 1.82 4.0202224 1.84 4.0202226 1.86
+ 4.0202228 1.88 4.020223 1.9 4.0202232 1.92 4.0202234 1.94 4.0202236 1.96 4.0202238 1.98
+ 4.020224 2 4.0202242 2.02 4.0202244 2.04 4.0202246 2.06 4.0202248 2.08 4.020225 2.1
+ 4.0202252 2.12 4.0202254 2.14 4.0202256 2.16 4.0202258 2.18 4.020226 2.2 4.0202262 2.22
+ 4.0202264 2.24 4.0202266 2.26 4.0202268 2.28 4.020227 2.3 4.0202272 2.32 4.0202274 2.34
+ 4.0202276 2.36 4.0202278 2.38 4.020228 2.4 4.020229 0 4.03031899 0 4.030318995 3
+ 4.030328995 3 4.030329 0 6.030329 0 6.03033 -0.2 6.0303302 -0.18 6.0303304 -0.16
+ 6.0303306 -0.14 6.0303308 -0.12 6.030331 -0.1 6.0303312 -0.08 6.0303314 -0.06 6.0303316 -0.04
+ 6.0303318 -0.02 6.030332 0 6.0303322 0.02 6.0303324 0.04 6.0303326 0.06 6.0303328 0.08
+ 6.030333 0.1 6.0303332 0.12 6.0303334 0.14 6.0303336 0.16 6.0303338 0.18 6.030334 0.2
+ 6.0303342 0.22 6.0303344 0.24 6.0303346 0.26 6.0303348 0.28 6.030335 0.3 6.0303352 0.32
+ 6.0303354 0.34 6.0303356 0.36 6.0303358 0.38 6.030336 0.4 6.0303362 0.42 6.0303364 0.44
+ 6.0303366 0.46 6.0303368 0.48 6.030337 0.5 6.0303372 0.52 6.0303374 0.54 6.0303376 0.56
+ 6.0303378 0.58 6.030338 0.6 6.0303382 0.62 6.0303384 0.64 6.0303386 0.66 6.0303388 0.68
+ 6.030339 0.7 6.0303392 0.72 6.0303394 0.74 6.0303396 0.76 6.0303398 0.78 6.03034 0.8
+ 6.0303402 0.82 6.0303404 0.84 6.0303406 0.86 6.0303408 0.88 6.030341 0.9 6.0303412 0.92
+ 6.0303414 0.94 6.0303416 0.96 6.0303418 0.98 6.030342 1 6.0303422 1.02 6.0303424 1.04
+ 6.0303426 1.06 6.0303428 1.08 6.030343 1.1 6.0303432 1.12 6.0303434 1.14 6.0303436 1.16
+ 6.0303438 1.18 6.030344 1.2 6.0303442 1.22 6.0303444 1.24 6.0303446 1.26 6.0303448 1.28
+ 6.030345 1.3 6.0303452 1.32 6.0303454 1.34 6.0303456 1.36 6.0303458 1.38 6.030346 1.4
+ 6.0303462 1.42 6.0303464 1.44 6.0303466 1.46 6.0303468 1.48 6.030347 1.5 6.0303472 1.52
+ 6.0303474 1.54 6.0303476 1.56 6.0303478 1.58 6.030348 1.6 6.0303482 1.62 6.0303484 1.64
+ 6.0303486 1.66 6.0303488 1.68 6.030349 1.7 6.0303492 1.72 6.0303494 1.74 6.0303496 1.76
+ 6.0303498 1.78 6.03035 1.8 6.0303502 1.82 6.0303504 1.84 6.0303506 1.86 6.0303508 1.88
+ 6.030351 1.9 6.0303512 1.92 6.0303514 1.94 6.0303516 1.96 6.0303518 1.98 6.030352 2
+ 6.0303522 2.02 6.0303524 2.04 6.0303526 2.06 6.0303528 2.08 6.030353 2.1 6.0303532 2.12
+ 6.0303534 2.14 6.0303536 2.16 6.0303538 2.18 6.030354 2.2 6.0303542 2.22 6.0303544 2.24
+ 6.0303546 2.26 6.0303548 2.28 6.030355 2.3 6.0303552 2.32 6.0303554 2.34 6.0303556 2.36
+ 6.0303558 2.38 6.030356 2.4 6.030357 0)
Vd10 d10 0 pwl(
+ 0 0 4.0202004 0 4.0202005 0.05 4.0202291 0.05 4.0202292 0 6.0303284 0
+ 6.0303285 0.05 6.0303571 0.05 6.0303572 0)
X10 g10 d10 0 0 fefet_c16
Vg11 g11 0 pwl(
+ 0 0 0.01009099 0 0.010090995 3.1 0.010100995 3.1 0.010101 0 2.02019099 0
+ 2.020190995 -3.1 2.020200995 -3.1 2.020201 0 4.020201 0 4.020202 -0.2 4.0202022 -0.18
+ 4.0202024 -0.16 4.0202026 -0.14 4.0202028 -0.12 4.020203 -0.1 4.0202032 -0.08 4.0202034 -0.06
+ 4.0202036 -0.04 4.0202038 -0.02 4.020204 0 4.0202042 0.02 4.0202044 0.04 4.0202046 0.06
+ 4.0202048 0.08 4.020205 0.1 4.0202052 0.12 4.0202054 0.14 4.0202056 0.16 4.0202058 0.18
+ 4.020206 0.2 4.0202062 0.22 4.0202064 0.24 4.0202066 0.26 4.0202068 0.28 4.020207 0.3
+ 4.0202072 0.32 4.0202074 0.34 4.0202076 0.36 4.0202078 0.38 4.020208 0.4 4.0202082 0.42
+ 4.0202084 0.44 4.0202086 0.46 4.0202088 0.48 4.020209 0.5 4.0202092 0.52 4.0202094 0.54
+ 4.0202096 0.56 4.0202098 0.58 4.02021 0.6 4.0202102 0.62 4.0202104 0.64 4.0202106 0.66
+ 4.0202108 0.68 4.020211 0.7 4.0202112 0.72 4.0202114 0.74 4.0202116 0.76 4.0202118 0.78
+ 4.020212 0.8 4.0202122 0.82 4.0202124 0.84 4.0202126 0.86 4.0202128 0.88 4.020213 0.9
+ 4.0202132 0.92 4.0202134 0.94 4.0202136 0.96 4.0202138 0.98 4.020214 1 4.0202142 1.02
+ 4.0202144 1.04 4.0202146 1.06 4.0202148 1.08 4.020215 1.1 4.0202152 1.12 4.0202154 1.14
+ 4.0202156 1.16 4.0202158 1.18 4.020216 1.2 4.0202162 1.22 4.0202164 1.24 4.0202166 1.26
+ 4.0202168 1.28 4.020217 1.3 4.0202172 1.32 4.0202174 1.34 4.0202176 1.36 4.0202178 1.38
+ 4.020218 1.4 4.0202182 1.42 4.0202184 1.44 4.0202186 1.46 4.0202188 1.48 4.020219 1.5
+ 4.0202192 1.52 4.0202194 1.54 4.0202196 1.56 4.0202198 1.58 4.02022 1.6 4.0202202 1.62
+ 4.0202204 1.64 4.0202206 1.66 4.0202208 1.68 4.020221 1.7 4.0202212 1.72 4.0202214 1.74
+ 4.0202216 1.76 4.0202218 1.78 4.020222 1.8 4.0202222 1.82 4.0202224 1.84 4.0202226 1.86
+ 4.0202228 1.88 4.020223 1.9 4.0202232 1.92 4.0202234 1.94 4.0202236 1.96 4.0202238 1.98
+ 4.020224 2 4.0202242 2.02 4.0202244 2.04 4.0202246 2.06 4.0202248 2.08 4.020225 2.1
+ 4.0202252 2.12 4.0202254 2.14 4.0202256 2.16 4.0202258 2.18 4.020226 2.2 4.0202262 2.22
+ 4.0202264 2.24 4.0202266 2.26 4.0202268 2.28 4.020227 2.3 4.0202272 2.32 4.0202274 2.34
+ 4.0202276 2.36 4.0202278 2.38 4.020228 2.4 4.020229 0 4.03031899 0 4.030318995 3.1
+ 4.030328995 3.1 4.030329 0 6.030329 0 6.03033 -0.2 6.0303302 -0.18 6.0303304 -0.16
+ 6.0303306 -0.14 6.0303308 -0.12 6.030331 -0.1 6.0303312 -0.08 6.0303314 -0.06 6.0303316 -0.04
+ 6.0303318 -0.02 6.030332 0 6.0303322 0.02 6.0303324 0.04 6.0303326 0.06 6.0303328 0.08
+ 6.030333 0.1 6.0303332 0.12 6.0303334 0.14 6.0303336 0.16 6.0303338 0.18 6.030334 0.2
+ 6.0303342 0.22 6.0303344 0.24 6.0303346 0.26 6.0303348 0.28 6.030335 0.3 6.0303352 0.32
+ 6.0303354 0.34 6.0303356 0.36 6.0303358 0.38 6.030336 0.4 6.0303362 0.42 6.0303364 0.44
+ 6.0303366 0.46 6.0303368 0.48 6.030337 0.5 6.0303372 0.52 6.0303374 0.54 6.0303376 0.56
+ 6.0303378 0.58 6.030338 0.6 6.0303382 0.62 6.0303384 0.64 6.0303386 0.66 6.0303388 0.68
+ 6.030339 0.7 6.0303392 0.72 6.0303394 0.74 6.0303396 0.76 6.0303398 0.78 6.03034 0.8
+ 6.0303402 0.82 6.0303404 0.84 6.0303406 0.86 6.0303408 0.88 6.030341 0.9 6.0303412 0.92
+ 6.0303414 0.94 6.0303416 0.96 6.0303418 0.98 6.030342 1 6.0303422 1.02 6.0303424 1.04
+ 6.0303426 1.06 6.0303428 1.08 6.030343 1.1 6.0303432 1.12 6.0303434 1.14 6.0303436 1.16
+ 6.0303438 1.18 6.030344 1.2 6.0303442 1.22 6.0303444 1.24 6.0303446 1.26 6.0303448 1.28
+ 6.030345 1.3 6.0303452 1.32 6.0303454 1.34 6.0303456 1.36 6.0303458 1.38 6.030346 1.4
+ 6.0303462 1.42 6.0303464 1.44 6.0303466 1.46 6.0303468 1.48 6.030347 1.5 6.0303472 1.52
+ 6.0303474 1.54 6.0303476 1.56 6.0303478 1.58 6.030348 1.6 6.0303482 1.62 6.0303484 1.64
+ 6.0303486 1.66 6.0303488 1.68 6.030349 1.7 6.0303492 1.72 6.0303494 1.74 6.0303496 1.76
+ 6.0303498 1.78 6.03035 1.8 6.0303502 1.82 6.0303504 1.84 6.0303506 1.86 6.0303508 1.88
+ 6.030351 1.9 6.0303512 1.92 6.0303514 1.94 6.0303516 1.96 6.0303518 1.98 6.030352 2
+ 6.0303522 2.02 6.0303524 2.04 6.0303526 2.06 6.0303528 2.08 6.030353 2.1 6.0303532 2.12
+ 6.0303534 2.14 6.0303536 2.16 6.0303538 2.18 6.030354 2.2 6.0303542 2.22 6.0303544 2.24
+ 6.0303546 2.26 6.0303548 2.28 6.030355 2.3 6.0303552 2.32 6.0303554 2.34 6.0303556 2.36
+ 6.0303558 2.38 6.030356 2.4 6.030357 0)
Vd11 d11 0 pwl(
+ 0 0 4.0202004 0 4.0202005 0.05 4.0202291 0.05 4.0202292 0 6.0303284 0
+ 6.0303285 0.05 6.0303571 0.05 6.0303572 0)
X11 g11 d11 0 0 fefet_c16
Vg12 g12 0 pwl(
+ 0 0 0.01009099 0 0.010090995 3.2 0.010100995 3.2 0.010101 0 2.02019099 0
+ 2.020190995 -3.2 2.020200995 -3.2 2.020201 0 4.020201 0 4.020202 -0.2 4.0202022 -0.18
+ 4.0202024 -0.16 4.0202026 -0.14 4.0202028 -0.12 4.020203 -0.1 4.0202032 -0.08 4.0202034 -0.06
+ 4.0202036 -0.04 4.0202038 -0.02 4.020204 0 4.0202042 0.02 4.0202044 0.04 4.0202046 0.06
+ 4.0202048 0.08 4.020205 0.1 4.0202052 0.12 4.0202054 0.14 4.0202056 0.16 4.0202058 0.18
+ 4.020206 0.2 4.0202062 0.22 4.0202064 0.24 4.0202066 0.26 4.0202068 0.28 4.020207 0.3
+ 4.0202072 0.32 4.0202074 0.34 4.0202076 0.36 4.0202078 0.38 4.020208 0.4 4.0202082 0.42
+ 4.0202084 0.44 4.0202086 0.46 4.0202088 0.48 4.020209 0.5 4.0202092 0.52 4.0202094 0.54
+ 4.0202096 0.56 4.0202098 0.58 4.02021 0.6 4.0202102 0.62 4.0202104 0.64 4.0202106 0.66
+ 4.0202108 0.68 4.020211 0.7 4.0202112 0.72 4.0202114 0.74 4.0202116 0.76 4.0202118 0.78
+ 4.020212 0.8 4.0202122 0.82 4.0202124 0.84 4.0202126 0.86 4.0202128 0.88 4.020213 0.9
+ 4.0202132 0.92 4.0202134 0.94 4.0202136 0.96 4.0202138 0.98 4.020214 1 4.0202142 1.02
+ 4.0202144 1.04 4.0202146 1.06 4.0202148 1.08 4.020215 1.1 4.0202152 1.12 4.0202154 1.14
+ 4.0202156 1.16 4.0202158 1.18 4.020216 1.2 4.0202162 1.22 4.0202164 1.24 4.0202166 1.26
+ 4.0202168 1.28 4.020217 1.3 4.0202172 1.32 4.0202174 1.34 4.0202176 1.36 4.0202178 1.38
+ 4.020218 1.4 4.0202182 1.42 4.0202184 1.44 4.0202186 1.46 4.0202188 1.48 4.020219 1.5
+ 4.0202192 1.52 4.0202194 1.54 4.0202196 1.56 4.0202198 1.58 4.02022 1.6 4.0202202 1.62
+ 4.0202204 1.64 4.0202206 1.66 4.0202208 1.68 4.020221 1.7 4.0202212 1.72 4.0202214 1.74
+ 4.0202216 1.76 4.0202218 1.78 4.020222 1.8 4.0202222 1.82 4.0202224 1.84 4.0202226 1.86
+ 4.0202228 1.88 4.020223 1.9 4.0202232 1.92 4.0202234 1.94 4.0202236 1.96 4.0202238 1.98
+ 4.020224 2 4.0202242 2.02 4.0202244 2.04 4.0202246 2.06 4.0202248 2.08 4.020225 2.1
+ 4.0202252 2.12 4.0202254 2.14 4.0202256 2.16 4.0202258 2.18 4.020226 2.2 4.0202262 2.22
+ 4.0202264 2.24 4.0202266 2.26 4.0202268 2.28 4.020227 2.3 4.0202272 2.32 4.0202274 2.34
+ 4.0202276 2.36 4.0202278 2.38 4.020228 2.4 4.020229 0 4.03031899 0 4.030318995 3.2
+ 4.030328995 3.2 4.030329 0 6.030329 0 6.03033 -0.2 6.0303302 -0.18 6.0303304 -0.16
+ 6.0303306 -0.14 6.0303308 -0.12 6.030331 -0.1 6.0303312 -0.08 6.0303314 -0.06 6.0303316 -0.04
+ 6.0303318 -0.02 6.030332 0 6.0303322 0.02 6.0303324 0.04 6.0303326 0.06 6.0303328 0.08
+ 6.030333 0.1 6.0303332 0.12 6.0303334 0.14 6.0303336 0.16 6.0303338 0.18 6.030334 0.2
+ 6.0303342 0.22 6.0303344 0.24 6.0303346 0.26 6.0303348 0.28 6.030335 0.3 6.0303352 0.32
+ 6.0303354 0.34 6.0303356 0.36 6.0303358 0.38 6.030336 0.4 6.0303362 0.42 6.0303364 0.44
+ 6.0303366 0.46 6.0303368 0.48 6.030337 0.5 6.0303372 0.52 6.0303374 0.54 6.0303376 0.56
+ 6.0303378 0.58 6.030338 0.6 6.0303382 0.62 6.0303384 0.64 6.0303386 0.66 6.0303388 0.68
+ 6.030339 0.7 6.0303392 0.72 6.0303394 0.74 6.0303396 0.76 6.0303398 0.78 6.03034 0.8
+ 6.0303402 0.82 6.0303404 0.84 6.0303406 0.86 6.0303408 0.88 6.030341 0.9 6.0303412 0.92
+ 6.0303414 0.94 6.0303416 0.96 6.0303418 0.98 6.030342 1 6.0303422 1.02 6.0303424 1.04
+ 6.0303426 1.06 6.0303428 1.08 6.030343 1.1 6.0303432 1.12 6.0303434 1.14 6.0303436 1.16
+ 6.0303438 1.18 6.030344 1.2 6.0303442 1.22 6.0303444 1.24 6.0303446 1.26 6.0303448 1.28
+ 6.030345 1.3 6.0303452 1.32 6.0303454 1.34 6.0303456 1.36 6.0303458 1.38 6.030346 1.4
+ 6.0303462 1.42 6.0303464 1.44 6.0303466 1.46 6.0303468 1.48 6.030347 1.5 6.0303472 1.52
+ 6.0303474 1.54 6.0303476 1.56 6.0303478 1.58 6.030348 1.6 6.0303482 1.62 6.0303484 1.64
+ 6.0303486 1.66 6.0303488 1.68 6.030349 1.7 6.0303492 1.72 6.0303494 1.74 6.0303496 1.76
+ 6.0303498 1.78 6.03035 1.8 6.0303502 1.82 6.0303504 1.84 6.0303506 1.86 6.0303508 1.88
+ 6.030351 1.9 6.0303512 1.92 6.0303514 1.94 6.0303516 1.96 6.0303518 1.98 6.030352 2
+ 6.0303522 2.02 6.0303524 2.04 6.0303526 2.06 6.0303528 2.08 6.030353 2.1 6.0303532 2.12
+ 6.0303534 2.14 6.0303536 2.16 6.0303538 2.18 6.030354 2.2 6.0303542 2.22 6.0303544 2.24
+ 6.0303546 2.26 6.0303548 2.28 6.030355 2.3 6.0303552 2.32 6.0303554 2.34 6.0303556 2.36
+ 6.0303558 2.38 6.030356 2.4 6.030357 0)
Vd12 d12 0 pwl(
+ 0 0 4.0202004 0 4.0202005 0.05 4.0202291 0.05 4.0202292 0 6.0303284 0
+ 6.0303285 0.05 6.0303571 0.05 6.0303572 0)
X12 g12 d12 0 0 fefet_c16
Vg13 g13 0 pwl(
+ 0 0 0.01009099 0 0.010090995 3.3 0.010100995 3.3 0.010101 0 2.02019099 0
+ 2.020190995 -3.3 2.020200995 -3.3 2.020201 0 4.020201 0 4.020202 -0.2 4.0202022 -0.18
+ 4.0202024 -0.16 4.0202026 -0.14 4.0202028 -0.12 4.020203 -0.1 4.0202032 -0.08 4.0202034 -0.06
+ 4.0202036 -0.04 4.0202038 -0.02 4.020204 0 4.0202042 0.02 4.0202044 0.04 4.0202046 0.06
+ 4.0202048 0.08 4.020205 0.1 4.0202052 0.12 4.0202054 0.14 4.0202056 0.16 4.0202058 0.18
+ 4.020206 0.2 4.0202062 0.22 4.0202064 0.24 4.0202066 0.26 4.0202068 0.28 4.020207 0.3
+ 4.0202072 0.32 4.0202074 0.34 4.0202076 0.36 4.0202078 0.38 4.020208 0.4 4.0202082 0.42
+ 4.0202084 0.44 4.0202086 0.46 4.0202088 0.48 4.020209 0.5 4.0202092 0.52 4.0202094 0.54
+ 4.0202096 0.56 4.0202098 0.58 4.02021 0.6 4.0202102 0.62 4.0202104 0.64 4.0202106 0.66
+ 4.0202108 0.68 4.020211 0.7 4.0202112 0.72 4.0202114 0.74 4.0202116 0.76 4.0202118 0.78
+ 4.020212 0.8 4.0202122 0.82 4.0202124 0.84 4.0202126 0.86 4.0202128 0.88 4.020213 0.9
+ 4.0202132 0.92 4.0202134 0.94 4.0202136 0.96 4.0202138 0.98 4.020214 1 4.0202142 1.02
+ 4.0202144 1.04 4.0202146 1.06 4.0202148 1.08 4.020215 1.1 4.0202152 1.12 4.0202154 1.14
+ 4.0202156 1.16 4.0202158 1.18 4.020216 1.2 4.0202162 1.22 4.0202164 1.24 4.0202166 1.26
+ 4.0202168 1.28 4.020217 1.3 4.0202172 1.32 4.0202174 1.34 4.0202176 1.36 4.0202178 1.38
+ 4.020218 1.4 4.0202182 1.42 4.0202184 1.44 4.0202186 1.46 4.0202188 1.48 4.020219 1.5
+ 4.0202192 1.52 4.0202194 1.54 4.0202196 1.56 4.0202198 1.58 4.02022 1.6 4.0202202 1.62
+ 4.0202204 1.64 4.0202206 1.66 4.0202208 1.68 4.020221 1.7 4.0202212 1.72 4.0202214 1.74
+ 4.0202216 1.76 4.0202218 1.78 4.020222 1.8 4.0202222 1.82 4.0202224 1.84 4.0202226 1.86
+ 4.0202228 1.88 4.020223 1.9 4.0202232 1.92 4.0202234 1.94 4.0202236 1.96 4.0202238 1.98
+ 4.020224 2 4.0202242 2.02 4.0202244 2.04 4.0202246 2.06 4.0202248 2.08 4.020225 2.1
+ 4.0202252 2.12 4.0202254 2.14 4.0202256 2.16 4.0202258 2.18 4.020226 2.2 4.0202262 2.22
+ 4.0202264 2.24 4.0202266 2.26 4.0202268 2.28 4.020227 2.3 4.0202272 2.32 4.0202274 2.34
+ 4.0202276 2.36 4.0202278 2.38 4.020228 2.4 4.020229 0 4.03031899 0 4.030318995 3.3
+ 4.030328995 3.3 4.030329 0 6.030329 0 6.03033 -0.2 6.0303302 -0.18 6.0303304 -0.16
+ 6.0303306 -0.14 6.0303308 -0.12 6.030331 -0.1 6.0303312 -0.08 6.0303314 -0.06 6.0303316 -0.04
+ 6.0303318 -0.02 6.030332 0 6.0303322 0.02 6.0303324 0.04 6.0303326 0.06 6.0303328 0.08
+ 6.030333 0.1 6.0303332 0.12 6.0303334 0.14 6.0303336 0.16 6.0303338 0.18 6.030334 0.2
+ 6.0303342 0.22 6.0303344 0.24 6.0303346 0.26 6.0303348 0.28 6.030335 0.3 6.0303352 0.32
+ 6.0303354 0.34 6.0303356 0.36 6.0303358 0.38 6.030336 0.4 6.0303362 0.42 6.0303364 0.44
+ 6.0303366 0.46 6.0303368 0.48 6.030337 0.5 6.0303372 0.52 6.0303374 0.54 6.0303376 0.56
+ 6.0303378 0.58 6.030338 0.6 6.0303382 0.62 6.0303384 0.64 6.0303386 0.66 6.0303388 0.68
+ 6.030339 0.7 6.0303392 0.72 6.0303394 0.74 6.0303396 0.76 6.0303398 0.78 6.03034 0.8
+ 6.0303402 0.82 6.0303404 0.84 6.0303406 0.86 6.0303408 0.88 6.030341 0.9 6.0303412 0.92
+ 6.0303414 0.94 6.0303416 0.96 6.0303418 0.98 6.030342 1 6.0303422 1.02 6.0303424 1.04
+ 6.0303426 1.06 6.0303428 1.08 6.030343 1.1 6.0303432 1.12 6.0303434 1.14 6.0303436 1.16
+ 6.0303438 1.18 6.030344 1.2 6.0303442 1.22 6.0303444 1.24 6.0303446 1.26 6.0303448 1.28
+ 6.030345 1.3 6.0303452 1.32 6.0303454 1.34 6.0303456 1.36 6.0303458 1.38 6.030346 1.4
+ 6.0303462 1.42 6.0303464 1.44 6.0303466 1.46 6.0303468 1.48 6.030347 1.5 6.0303472 1.52
+ 6.0303474 1.54 6.0303476 1.56 6.0303478 1.58 6.030348 1.6 6.0303482 1.62 6.0303484 1.64
+ 6.0303486 1.66 6.0303488 1.68 6.030349 1.7 6.0303492 1.72 6.0303494 1.74 6.0303496 1.76
+ 6.0303498 1.78 6.03035 1.8 6.0303502 1.82 6.0303504 1.84 6.0303506 1.86 6.0303508 1.88
+ 6.030351 1.9 6.0303512 1.92 6.0303514 1.94 6.0303516 1.96 6.0303518 1.98 6.030352 2
+ 6.0303522 2.02 6.0303524 2.04 6.0303526 2.06 6.0303528 2.08 6.030353 2.1 6.0303532 2.12
+ 6.0303534 2.14 6.0303536 2.16 6.0303538 2.18 6.030354 2.2 6.0303542 2.22 6.0303544 2.24
+ 6.0303546 2.26 6.0303548 2.28 6.030355 2.3 6.0303552 2.32 6.0303554 2.34 6.0303556 2.36
+ 6.0303558 2.38 6.030356 2.4 6.030357 0)
Vd13 d13 0 pwl(
+ 0 0 4.0202004 0 4.0202005 0.05 4.0202291 0.05 4.0202292 0 6.0303284 0
+ 6.0303285 0.05 6.0303571 0.05 6.0303572 0)
X13 g13 d13 0 0 fefet_c16
Vg14 g14 0 pwl(
+ 0 0 0.01009099 0 0.010090995 3.4 0.010100995 3.4 0.010101 0 2.02019099 0
+ 2.020190995 -3.4 2.020200995 -3.4 2.020201 0 4.020201 0 4.020202 -0.2 4.0202022 -0.18
+ 4.0202024 -0.16 4.0202026 -0.14 4.0202028 -0.12 4.020203 -0.1 4.0202032 -0.08 4.0202034 -0.06
+ 4.0202036 -0.04 4.0202038 -0.02 4.020204 0 4.0202042 0.02 4.0202044 0.04 4.0202046 0.06
+ 4.0202048 0.08 4.020205 0.1 4.0202052 0.12 4.0202054 0.14 4.0202056 0.16 4.0202058 0.18
+ 4.020206 0.2 4.0202062 0.22 4.0202064 0.24 4.0202066 0.26 4.0202068 0.28 4.020207 0.3
+ 4.0202072 0.32 4.0202074 0.34 4.0202076 0.36 4.0202078 0.38 4.020208 0.4 4.0202082 0.42
+ 4.0202084 0.44 4.0202086 0.46 4.0202088 0.48 4.020209 0.5 4.0202092 0.52 4.0202094 0.54
+ 4.0202096 0.56 4.0202098 0.58 4.02021 0.6 4.0202102 0.62 4.0202104 0.64 4.0202106 0.66
+ 4.0202108 0.68 4.020211 0.7 4.0202112 0.72 4.0202114 0.74 4.0202116 0.76 4.0202118 0.78
+ 4.020212 0.8 4.0202122 0.82 4.0202124 0.84 4.0202126 0.86 4.0202128 0.88 4.020213 0.9
+ 4.0202132 0.92 4.0202134 0.94 4.0202136 0.96 4.0202138 0.98 4.020214 1 4.0202142 1.02
+ 4.0202144 1.04 4.0202146 1.06 4.0202148 1.08 4.020215 1.1 4.0202152 1.12 4.0202154 1.14
+ 4.0202156 1.16 4.0202158 1.18 4.020216 1.2 4.0202162 1.22 4.0202164 1.24 4.0202166 1.26
+ 4.0202168 1.28 4.020217 1.3 4.0202172 1.32 4.0202174 1.34 4.0202176 1.36 4.0202178 1.38
+ 4.020218 1.4 4.0202182 1.42 4.0202184 1.44 4.0202186 1.46 4.0202188 1.48 4.020219 1.5
+ 4.0202192 1.52 4.0202194 1.54 4.0202196 1.56 4.0202198 1.58 4.02022 1.6 4.0202202 1.62
+ 4.0202204 1.64 4.0202206 1.66 4.0202208 1.68 4.020221 1.7 4.0202212 1.72 4.0202214 1.74
+ 4.0202216 1.76 4.0202218 1.78 4.020222 1.8 4.0202222 1.82 4.0202224 1.84 4.0202226 1.86
+ 4.0202228 1.88 4.020223 1.9 4.0202232 1.92 4.0202234 1.94 4.0202236 1.96 4.0202238 1.98
+ 4.020224 2 4.0202242 2.02 4.0202244 2.04 4.0202246 2.06 4.0202248 2.08 4.020225 2.1
+ 4.0202252 2.12 4.0202254 2.14 4.0202256 2.16 4.0202258 2.18 4.020226 2.2 4.0202262 2.22
+ 4.0202264 2.24 4.0202266 2.26 4.0202268 2.28 4.020227 2.3 4.0202272 2.32 4.0202274 2.34
+ 4.0202276 2.36 4.0202278 2.38 4.020228 2.4 4.020229 0 4.03031899 0 4.030318995 3.4
+ 4.030328995 3.4 4.030329 0 6.030329 0 6.03033 -0.2 6.0303302 -0.18 6.0303304 -0.16
+ 6.0303306 -0.14 6.0303308 -0.12 6.030331 -0.1 6.0303312 -0.08 6.0303314 -0.06 6.0303316 -0.04
+ 6.0303318 -0.02 6.030332 0 6.0303322 0.02 6.0303324 0.04 6.0303326 0.06 6.0303328 0.08
+ 6.030333 0.1 6.0303332 0.12 6.0303334 0.14 6.0303336 0.16 6.0303338 0.18 6.030334 0.2
+ 6.0303342 0.22 6.0303344 0.24 6.0303346 0.26 6.0303348 0.28 6.030335 0.3 6.0303352 0.32
+ 6.0303354 0.34 6.0303356 0.36 6.0303358 0.38 6.030336 0.4 6.0303362 0.42 6.0303364 0.44
+ 6.0303366 0.46 6.0303368 0.48 6.030337 0.5 6.0303372 0.52 6.0303374 0.54 6.0303376 0.56
+ 6.0303378 0.58 6.030338 0.6 6.0303382 0.62 6.0303384 0.64 6.0303386 0.66 6.0303388 0.68
+ 6.030339 0.7 6.0303392 0.72 6.0303394 0.74 6.0303396 0.76 6.0303398 0.78 6.03034 0.8
+ 6.0303402 0.82 6.0303404 0.84 6.0303406 0.86 6.0303408 0.88 6.030341 0.9 6.0303412 0.92
+ 6.0303414 0.94 6.0303416 0.96 6.0303418 0.98 6.030342 1 6.0303422 1.02 6.0303424 1.04
+ 6.0303426 1.06 6.0303428 1.08 6.030343 1.1 6.0303432 1.12 6.0303434 1.14 6.0303436 1.16
+ 6.0303438 1.18 6.030344 1.2 6.0303442 1.22 6.0303444 1.24 6.0303446 1.26 6.0303448 1.28
+ 6.030345 1.3 6.0303452 1.32 6.0303454 1.34 6.0303456 1.36 6.0303458 1.38 6.030346 1.4
+ 6.0303462 1.42 6.0303464 1.44 6.0303466 1.46 6.0303468 1.48 6.030347 1.5 6.0303472 1.52
+ 6.0303474 1.54 6.0303476 1.56 6.0303478 1.58 6.030348 1.6 6.0303482 1.62 6.0303484 1.64
+ 6.0303486 1.66 6.0303488 1.68 6.030349 1.7 6.0303492 1.72 6.0303494 1.74 6.0303496 1.76
+ 6.0303498 1.78 6.03035 1.8 6.0303502 1.82 6.0303504 1.84 6.0303506 1.86 6.0303508 1.88
+ 6.030351 1.9 6.0303512 1.92 6.0303514 1.94 6.0303516 1.96 6.0303518 1.98 6.030352 2
+ 6.0303522 2.02 6.0303524 2.04 6.0303526 2.06 6.0303528 2.08 6.030353 2.1 6.0303532 2.12
+ 6.0303534 2.14 6.0303536 2.16 6.0303538 2.18 6.030354 2.2 6.0303542 2.22 6.0303544 2.24
+ 6.0303546 2.26 6.0303548 2.28 6.030355 2.3 6.0303552 2.32 6.0303554 2.34 6.0303556 2.36
+ 6.0303558 2.38 6.030356 2.4 6.030357 0)
Vd14 d14 0 pwl(
+ 0 0 4.0202004 0 4.0202005 0.05 4.0202291 0.05 4.0202292 0 6.0303284 0
+ 6.0303285 0.05 6.0303571 0.05 6.0303572 0)
X14 g14 d14 0 0 fefet_c16
Vg15 g15 0 pwl(
+ 0 0 0.01009099 0 0.010090995 3.5 0.010100995 3.5 0.010101 0 2.02019099 0
+ 2.020190995 -3.5 2.020200995 -3.5 2.020201 0 4.020201 0 4.020202 -0.2 4.0202022 -0.18
+ 4.0202024 -0.16 4.0202026 -0.14 4.0202028 -0.12 4.020203 -0.1 4.0202032 -0.08 4.0202034 -0.06
+ 4.0202036 -0.04 4.0202038 -0.02 4.020204 0 4.0202042 0.02 4.0202044 0.04 4.0202046 0.06
+ 4.0202048 0.08 4.020205 0.1 4.0202052 0.12 4.0202054 0.14 4.0202056 0.16 4.0202058 0.18
+ 4.020206 0.2 4.0202062 0.22 4.0202064 0.24 4.0202066 0.26 4.0202068 0.28 4.020207 0.3
+ 4.0202072 0.32 4.0202074 0.34 4.0202076 0.36 4.0202078 0.38 4.020208 0.4 4.0202082 0.42
+ 4.0202084 0.44 4.0202086 0.46 4.0202088 0.48 4.020209 0.5 4.0202092 0.52 4.0202094 0.54
+ 4.0202096 0.56 4.0202098 0.58 4.02021 0.6 4.0202102 0.62 4.0202104 0.64 4.0202106 0.66
+ 4.0202108 0.68 4.020211 0.7 4.0202112 0.72 4.0202114 0.74 4.0202116 0.76 4.0202118 0.78
+ 4.020212 0.8 4.0202122 0.82 4.0202124 0.84 4.0202126 0.86 4.0202128 0.88 4.020213 0.9
+ 4.0202132 0.92 4.0202134 0.94 4.0202136 0.96 4.0202138 0.98 4.020214 1 4.0202142 1.02
+ 4.0202144 1.04 4.0202146 1.06 4.0202148 1.08 4.020215 1.1 4.0202152 1.12 4.0202154 1.14
+ 4.0202156 1.16 4.0202158 1.18 4.020216 1.2 4.0202162 1.22 4.0202164 1.24 4.0202166 1.26
+ 4.0202168 1.28 4.020217 1.3 4.0202172 1.32 4.0202174 1.34 4.0202176 1.36 4.0202178 1.38
+ 4.020218 1.4 4.0202182 1.42 4.0202184 1.44 4.0202186 1.46 4.0202188 1.48 4.020219 1.5
+ 4.0202192 1.52 4.0202194 1.54 4.0202196 1.56 4.0202198 1.58 4.02022 1.6 4.0202202 1.62
+ 4.0202204 1.64 4.0202206 1.66 4.0202208 1.68 4.020221 1.7 4.0202212 1.72 4.0202214 1.74
+ 4.0202216 1.76 4.0202218 1.78 4.020222 1.8 4.0202222 1.82 4.0202224 1.84 4.0202226 1.86
+ 4.0202228 1.88 4.020223 1.9 4.0202232 1.92 4.0202234 1.94 4.0202236 1.96 4.0202238 1.98
+ 4.020224 2 4.0202242 2.02 4.0202244 2.04 4.0202246 2.06 4.0202248 2.08 4.020225 2.1
+ 4.0202252 2.12 4.0202254 2.14 4.0202256 2.16 4.0202258 2.18 4.020226 2.2 4.0202262 2.22
+ 4.0202264 2.24 4.0202266 2.26 4.0202268 2.28 4.020227 2.3 4.0202272 2.32 4.0202274 2.34
+ 4.0202276 2.36 4.0202278 2.38 4.020228 2.4 4.020229 0 4.03031899 0 4.030318995 3.5
+ 4.030328995 3.5 4.030329 0 6.030329 0 6.03033 -0.2 6.0303302 -0.18 6.0303304 -0.16
+ 6.0303306 -0.14 6.0303308 -0.12 6.030331 -0.1 6.0303312 -0.08 6.0303314 -0.06 6.0303316 -0.04
+ 6.0303318 -0.02 6.030332 0 6.0303322 0.02 6.0303324 0.04 6.0303326 0.06 6.0303328 0.08
+ 6.030333 0.1 6.0303332 0.12 6.0303334 0.14 6.0303336 0.16 6.0303338 0.18 6.030334 0.2
+ 6.0303342 0.22 6.0303344 0.24 6.0303346 0.26 6.0303348 0.28 6.030335 0.3 6.0303352 0.32
+ 6.0303354 0.34 6.0303356 0.36 6.0303358 0.38 6.030336 0.4 6.0303362 0.42 6.0303364 0.44
+ 6.0303366 0.46 6.0303368 0.48 6.030337 0.5 6.0303372 0.52 6.0303374 0.54 6.0303376 0.56
+ 6.0303378 0.58 6.030338 0.6 6.0303382 0.62 6.0303384 0.64 6.0303386 0.66 6.0303388 0.68
+ 6.030339 0.7 6.0303392 0.72 6.0303394 0.74 6.0303396 0.76 6.0303398 0.78 6.03034 0.8
+ 6.0303402 0.82 6.0303404 0.84 6.0303406 0.86 6.0303408 0.88 6.030341 0.9 6.0303412 0.92
+ 6.0303414 0.94 6.0303416 0.96 6.0303418 0.98 6.030342 1 6.0303422 1.02 6.0303424 1.04
+ 6.0303426 1.06 6.0303428 1.08 6.030343 1.1 6.0303432 1.12 6.0303434 1.14 6.0303436 1.16
+ 6.0303438 1.18 6.030344 1.2 6.0303442 1.22 6.0303444 1.24 6.0303446 1.26 6.0303448 1.28
+ 6.030345 1.3 6.0303452 1.32 6.0303454 1.34 6.0303456 1.36 6.0303458 1.38 6.030346 1.4
+ 6.0303462 1.42 6.0303464 1.44 6.0303466 1.46 6.0303468 1.48 6.030347 1.5 6.0303472 1.52
+ 6.0303474 1.54 6.0303476 1.56 6.0303478 1.58 6.030348 1.6 6.0303482 1.62 6.0303484 1.64
+ 6.0303486 1.66 6.0303488 1.68 6.030349 1.7 6.0303492 1.72 6.0303494 1.74 6.0303496 1.76
+ 6.0303498 1.78 6.03035 1.8 6.0303502 1.82 6.0303504 1.84 6.0303506 1.86 6.0303508 1.88
+ 6.030351 1.9 6.0303512 1.92 6.0303514 1.94 6.0303516 1.96 6.0303518 1.98 6.030352 2
+ 6.0303522 2.02 6.0303524 2.04 6.0303526 2.06 6.0303528 2.08 6.030353 2.1 6.0303532 2.12
+ 6.0303534 2.14 6.0303536 2.16 6.0303538 2.18 6.030354 2.2 6.0303542 2.22 6.0303544 2.24
+ 6.0303546 2.26 6.0303548 2.28 6.030355 2.3 6.0303552 2.32 6.0303554 2.34 6.0303556 2.36
+ 6.0303558 2.38 6.030356 2.4 6.030357 0)
Vd15 d15 0 pwl(
+ 0 0 4.0202004 0 4.0202005 0.05 4.0202291 0.05 4.0202292 0 6.0303284 0
+ 6.0303285 0.05 6.0303571 0.05 6.0303572 0)
X15 g15 d15 0 0 fefet_c16
Vg16 g16 0 pwl(
+ 0 0 0.01009099 0 0.010090995 3.6 0.010100995 3.6 0.010101 0 2.02019099 0
+ 2.020190995 -3.6 2.020200995 -3.6 2.020201 0 4.020201 0 4.020202 -0.2 4.0202022 -0.18
+ 4.0202024 -0.16 4.0202026 -0.14 4.0202028 -0.12 4.020203 -0.1 4.0202032 -0.08 4.0202034 -0.06
+ 4.0202036 -0.04 4.0202038 -0.02 4.020204 0 4.0202042 0.02 4.0202044 0.04 4.0202046 0.06
+ 4.0202048 0.08 4.020205 0.1 4.0202052 0.12 4.0202054 0.14 4.0202056 0.16 4.0202058 0.18
+ 4.020206 0.2 4.0202062 0.22 4.0202064 0.24 4.0202066 0.26 4.0202068 0.28 4.020207 0.3
+ 4.0202072 0.32 4.0202074 0.34 4.0202076 0.36 4.0202078 0.38 4.020208 0.4 4.0202082 0.42
+ 4.0202084 0.44 4.0202086 0.46 4.0202088 0.48 4.020209 0.5 4.0202092 0.52 4.0202094 0.54
+ 4.0202096 0.56 4.0202098 0.58 4.02021 0.6 4.0202102 0.62 4.0202104 0.64 4.0202106 0.66
+ 4.0202108 0.68 4.020211 0.7 4.0202112 0.72 4.0202114 0.74 4.0202116 0.76 4.0202118 0.78
+ 4.020212 0.8 4.0202122 0.82 4.0202124 0.84 4.0202126 0.86 4.0202128 0.88 4.020213 0.9
+ 4.0202132 0.92 4.0202134 0.94 4.0202136 0.96 4.0202138 0.98 4.020214 1 4.0202142 1.02
+ 4.0202144 1.04 4.0202146 1.06 4.0202148 1.08 4.020215 1.1 4.0202152 1.12 4.0202154 1.14
+ 4.0202156 1.16 4.0202158 1.18 4.020216 1.2 4.0202162 1.22 4.0202164 1.24 4.0202166 1.26
+ 4.0202168 1.28 4.020217 1.3 4.0202172 1.32 4.0202174 1.34 4.0202176 1.36 4.0202178 1.38
+ 4.020218 1.4 4.0202182 1.42 4.0202184 1.44 4.0202186 1.46 4.0202188 1.48 4.020219 1.5
+ 4.0202192 1.52 4.0202194 1.54 4.0202196 1.56 4.0202198 1.58 4.02022 1.6 4.0202202 1.62
+ 4.0202204 1.64 4.0202206 1.66 4.0202208 1.68 4.020221 1.7 4.0202212 1.72 4.0202214 1.74
+ 4.0202216 1.76 4.0202218 1.78 4.020222 1.8 4.0202222 1.82 4.0202224 1.84 4.0202226 1.86
+ 4.0202228 1.88 4.020223 1.9 4.0202232 1.92 4.0202234 1.94 4.0202236 1.96 4.0202238 1.98
+ 4.020224 2 4.0202242 2.02 4.0202244 2.04 4.0202246 2.06 4.0202248 2.08 4.020225 2.1
+ 4.0202252 2.12 4.0202254 2.14 4.0202256 2.16 4.0202258 2.18 4.020226 2.2 4.0202262 2.22
+ 4.0202264 2.24 4.0202266 2.26 4.0202268 2.28 4.020227 2.3 4.0202272 2.32 4.0202274 2.34
+ 4.0202276 2.36 4.0202278 2.38 4.020228 2.4 4.020229 0 4.03031899 0 4.030318995 3.6
+ 4.030328995 3.6 4.030329 0 6.030329 0 6.03033 -0.2 6.0303302 -0.18 6.0303304 -0.16
+ 6.0303306 -0.14 6.0303308 -0.12 6.030331 -0.1 6.0303312 -0.08 6.0303314 -0.06 6.0303316 -0.04
+ 6.0303318 -0.02 6.030332 0 6.0303322 0.02 6.0303324 0.04 6.0303326 0.06 6.0303328 0.08
+ 6.030333 0.1 6.0303332 0.12 6.0303334 0.14 6.0303336 0.16 6.0303338 0.18 6.030334 0.2
+ 6.0303342 0.22 6.0303344 0.24 6.0303346 0.26 6.0303348 0.28 6.030335 0.3 6.0303352 0.32
+ 6.0303354 0.34 6.0303356 0.36 6.0303358 0.38 6.030336 0.4 6.0303362 0.42 6.0303364 0.44
+ 6.0303366 0.46 6.0303368 0.48 6.030337 0.5 6.0303372 0.52 6.0303374 0.54 6.0303376 0.56
+ 6.0303378 0.58 6.030338 0.6 6.0303382 0.62 6.0303384 0.64 6.0303386 0.66 6.0303388 0.68
+ 6.030339 0.7 6.0303392 0.72 6.0303394 0.74 6.0303396 0.76 6.0303398 0.78 6.03034 0.8
+ 6.0303402 0.82 6.0303404 0.84 6.0303406 0.86 6.0303408 0.88 6.030341 0.9 6.0303412 0.92
+ 6.0303414 0.94 6.0303416 0.96 6.0303418 0.98 6.030342 1 6.0303422 1.02 6.0303424 1.04
+ 6.0303426 1.06 6.0303428 1.08 6.030343 1.1 6.0303432 1.12 6.0303434 1.14 6.0303436 1.16
+ 6.0303438 1.18 6.030344 1.2 6.0303442 1.22 6.0303444 1.24 6.0303446 1.26 6.0303448 1.28
+ 6.030345 1.3 6.0303452 1.32 6.0303454 1.34 6.0303456 1.36 6.0303458 1.38 6.030346 1.4
+ 6.0303462 1.42 6.0303464 1.44 6.0303466 1.46 6.0303468 1.48 6.030347 1.5 6.0303472 1.52
+ 6.0303474 1.54 6.0303476 1.56 6.0303478 1.58 6.030348 1.6 6.0303482 1.62 6.0303484 1.64
+ 6.0303486 1.66 6.0303488 1.68 6.030349 1.7 6.0303492 1.72 6.0303494 1.74 6.0303496 1.76
+ 6.0303498 1.78 6.03035 1.8 6.0303502 1.82 6.0303504 1.84 6.0303506 1.86 6.0303508 1.88
+ 6.030351 1.9 6.0303512 1.92 6.0303514 1.94 6.0303516 1.96 6.0303518 1.98 6.030352 2
+ 6.0303522 2.02 6.0303524 2.04 6.0303526 2.06 6.0303528 2.08 6.030353 2.1 6.0303532 2.12
+ 6.0303534 2.14 6.0303536 2.16 6.0303538 2.18 6.030354 2.2 6.0303542 2.22 6.0303544 2.24
+ 6.0303546 2.26 6.0303548 2.28 6.030355 2.3 6.0303552 2.32 6.0303554 2.34 6.0303556 2.36
+ 6.0303558 2.38 6.030356 2.4 6.030357 0)
Vd16 d16 0 pwl(
+ 0 0 4.0202004 0 4.0202005 0.05 4.0202291 0.05 4.0202292 0 6.0303284 0
+ 6.0303285 0.05 6.0303571 0.05 6.0303572 0)
X16 g16 d16 0 0 fefet_c16
Vg17 g17 0 pwl(
+ 0 0 0.01009099 0 0.010090995 3.7 0.010100995 3.7 0.010101 0 2.02019099 0
+ 2.020190995 -3.7 2.020200995 -3.7 2.020201 0 4.020201 0 4.020202 -0.2 4.0202022 -0.18
+ 4.0202024 -0.16 4.0202026 -0.14 4.0202028 -0.12 4.020203 -0.1 4.0202032 -0.08 4.0202034 -0.06
+ 4.0202036 -0.04 4.0202038 -0.02 4.020204 0 4.0202042 0.02 4.0202044 0.04 4.0202046 0.06
+ 4.0202048 0.08 4.020205 0.1 4.0202052 0.12 4.0202054 0.14 4.0202056 0.16 4.0202058 0.18
+ 4.020206 0.2 4.0202062 0.22 4.0202064 0.24 4.0202066 0.26 4.0202068 0.28 4.020207 0.3
+ 4.0202072 0.32 4.0202074 0.34 4.0202076 0.36 4.0202078 0.38 4.020208 0.4 4.0202082 0.42
+ 4.0202084 0.44 4.0202086 0.46 4.0202088 0.48 4.020209 0.5 4.0202092 0.52 4.0202094 0.54
+ 4.0202096 0.56 4.0202098 0.58 4.02021 0.6 4.0202102 0.62 4.0202104 0.64 4.0202106 0.66
+ 4.0202108 0.68 4.020211 0.7 4.0202112 0.72 4.0202114 0.74 4.0202116 0.76 4.0202118 0.78
+ 4.020212 0.8 4.0202122 0.82 4.0202124 0.84 4.0202126 0.86 4.0202128 0.88 4.020213 0.9
+ 4.0202132 0.92 4.0202134 0.94 4.0202136 0.96 4.0202138 0.98 4.020214 1 4.0202142 1.02
+ 4.0202144 1.04 4.0202146 1.06 4.0202148 1.08 4.020215 1.1 4.0202152 1.12 4.0202154 1.14
+ 4.0202156 1.16 4.0202158 1.18 4.020216 1.2 4.0202162 1.22 4.0202164 1.24 4.0202166 1.26
+ 4.0202168 1.28 4.020217 1.3 4.0202172 1.32 4.0202174 1.34 4.0202176 1.36 4.0202178 1.38
+ 4.020218 1.4 4.0202182 1.42 4.0202184 1.44 4.0202186 1.46 4.0202188 1.48 4.020219 1.5
+ 4.0202192 1.52 4.0202194 1.54 4.0202196 1.56 4.0202198 1.58 4.02022 1.6 4.0202202 1.62
+ 4.0202204 1.64 4.0202206 1.66 4.0202208 1.68 4.020221 1.7 4.0202212 1.72 4.0202214 1.74
+ 4.0202216 1.76 4.0202218 1.78 4.020222 1.8 4.0202222 1.82 4.0202224 1.84 4.0202226 1.86
+ 4.0202228 1.88 4.020223 1.9 4.0202232 1.92 4.0202234 1.94 4.0202236 1.96 4.0202238 1.98
+ 4.020224 2 4.0202242 2.02 4.0202244 2.04 4.0202246 2.06 4.0202248 2.08 4.020225 2.1
+ 4.0202252 2.12 4.0202254 2.14 4.0202256 2.16 4.0202258 2.18 4.020226 2.2 4.0202262 2.22
+ 4.0202264 2.24 4.0202266 2.26 4.0202268 2.28 4.020227 2.3 4.0202272 2.32 4.0202274 2.34
+ 4.0202276 2.36 4.0202278 2.38 4.020228 2.4 4.020229 0 4.03031899 0 4.030318995 3.7
+ 4.030328995 3.7 4.030329 0 6.030329 0 6.03033 -0.2 6.0303302 -0.18 6.0303304 -0.16
+ 6.0303306 -0.14 6.0303308 -0.12 6.030331 -0.1 6.0303312 -0.08 6.0303314 -0.06 6.0303316 -0.04
+ 6.0303318 -0.02 6.030332 0 6.0303322 0.02 6.0303324 0.04 6.0303326 0.06 6.0303328 0.08
+ 6.030333 0.1 6.0303332 0.12 6.0303334 0.14 6.0303336 0.16 6.0303338 0.18 6.030334 0.2
+ 6.0303342 0.22 6.0303344 0.24 6.0303346 0.26 6.0303348 0.28 6.030335 0.3 6.0303352 0.32
+ 6.0303354 0.34 6.0303356 0.36 6.0303358 0.38 6.030336 0.4 6.0303362 0.42 6.0303364 0.44
+ 6.0303366 0.46 6.0303368 0.48 6.030337 0.5 6.0303372 0.52 6.0303374 0.54 6.0303376 0.56
+ 6.0303378 0.58 6.030338 0.6 6.0303382 0.62 6.0303384 0.64 6.0303386 0.66 6.0303388 0.68
+ 6.030339 0.7 6.0303392 0.72 6.0303394 0.74 6.0303396 0.76 6.0303398 0.78 6.03034 0.8
+ 6.0303402 0.82 6.0303404 0.84 6.0303406 0.86 6.0303408 0.88 6.030341 0.9 6.0303412 0.92
+ 6.0303414 0.94 6.0303416 0.96 6.0303418 0.98 6.030342 1 6.0303422 1.02 6.0303424 1.04
+ 6.0303426 1.06 6.0303428 1.08 6.030343 1.1 6.0303432 1.12 6.0303434 1.14 6.0303436 1.16
+ 6.0303438 1.18 6.030344 1.2 6.0303442 1.22 6.0303444 1.24 6.0303446 1.26 6.0303448 1.28
+ 6.030345 1.3 6.0303452 1.32 6.0303454 1.34 6.0303456 1.36 6.0303458 1.38 6.030346 1.4
+ 6.0303462 1.42 6.0303464 1.44 6.0303466 1.46 6.0303468 1.48 6.030347 1.5 6.0303472 1.52
+ 6.0303474 1.54 6.0303476 1.56 6.0303478 1.58 6.030348 1.6 6.0303482 1.62 6.0303484 1.64
+ 6.0303486 1.66 6.0303488 1.68 6.030349 1.7 6.0303492 1.72 6.0303494 1.74 6.0303496 1.76
+ 6.0303498 1.78 6.03035 1.8 6.0303502 1.82 6.0303504 1.84 6.0303506 1.86 6.0303508 1.88
+ 6.030351 1.9 6.0303512 1.92 6.0303514 1.94 6.0303516 1.96 6.0303518 1.98 6.030352 2
+ 6.0303522 2.02 6.0303524 2.04 6.0303526 2.06 6.0303528 2.08 6.030353 2.1 6.0303532 2.12
+ 6.0303534 2.14 6.0303536 2.16 6.0303538 2.18 6.030354 2.2 6.0303542 2.22 6.0303544 2.24
+ 6.0303546 2.26 6.0303548 2.28 6.030355 2.3 6.0303552 2.32 6.0303554 2.34 6.0303556 2.36
+ 6.0303558 2.38 6.030356 2.4 6.030357 0)
Vd17 d17 0 pwl(
+ 0 0 4.0202004 0 4.0202005 0.05 4.0202291 0.05 4.0202292 0 6.0303284 0
+ 6.0303285 0.05 6.0303571 0.05 6.0303572 0)
X17 g17 d17 0 0 fefet_c16
Vg18 g18 0 pwl(
+ 0 0 0.01009099 0 0.010090995 3.8 0.010100995 3.8 0.010101 0 2.02019099 0
+ 2.020190995 -3.8 2.020200995 -3.8 2.020201 0 4.020201 0 4.020202 -0.2 4.0202022 -0.18
+ 4.0202024 -0.16 4.0202026 -0.14 4.0202028 -0.12 4.020203 -0.1 4.0202032 -0.08 4.0202034 -0.06
+ 4.0202036 -0.04 4.0202038 -0.02 4.020204 0 4.0202042 0.02 4.0202044 0.04 4.0202046 0.06
+ 4.0202048 0.08 4.020205 0.1 4.0202052 0.12 4.0202054 0.14 4.0202056 0.16 4.0202058 0.18
+ 4.020206 0.2 4.0202062 0.22 4.0202064 0.24 4.0202066 0.26 4.0202068 0.28 4.020207 0.3
+ 4.0202072 0.32 4.0202074 0.34 4.0202076 0.36 4.0202078 0.38 4.020208 0.4 4.0202082 0.42
+ 4.0202084 0.44 4.0202086 0.46 4.0202088 0.48 4.020209 0.5 4.0202092 0.52 4.0202094 0.54
+ 4.0202096 0.56 4.0202098 0.58 4.02021 0.6 4.0202102 0.62 4.0202104 0.64 4.0202106 0.66
+ 4.0202108 0.68 4.020211 0.7 4.0202112 0.72 4.0202114 0.74 4.0202116 0.76 4.0202118 0.78
+ 4.020212 0.8 4.0202122 0.82 4.0202124 0.84 4.0202126 0.86 4.0202128 0.88 4.020213 0.9
+ 4.0202132 0.92 4.0202134 0.94 4.0202136 0.96 4.0202138 0.98 4.020214 1 4.0202142 1.02
+ 4.0202144 1.04 4.0202146 1.06 4.0202148 1.08 4.020215 1.1 4.0202152 1.12 4.0202154 1.14
+ 4.0202156 1.16 4.0202158 1.18 4.020216 1.2 4.0202162 1.22 4.0202164 1.24 4.0202166 1.26
+ 4.0202168 1.28 4.020217 1.3 4.0202172 1.32 4.0202174 1.34 4.0202176 1.36 4.0202178 1.38
+ 4.020218 1.4 4.0202182 1.42 4.0202184 1.44 4.0202186 1.46 4.0202188 1.48 4.020219 1.5
+ 4.0202192 1.52 4.0202194 1.54 4.0202196 1.56 4.0202198 1.58 4.02022 1.6 4.0202202 1.62
+ 4.0202204 1.64 4.0202206 1.66 4.0202208 1.68 4.020221 1.7 4.0202212 1.72 4.0202214 1.74
+ 4.0202216 1.76 4.0202218 1.78 4.020222 1.8 4.0202222 1.82 4.0202224 1.84 4.0202226 1.86
+ 4.0202228 1.88 4.020223 1.9 4.0202232 1.92 4.0202234 1.94 4.0202236 1.96 4.0202238 1.98
+ 4.020224 2 4.0202242 2.02 4.0202244 2.04 4.0202246 2.06 4.0202248 2.08 4.020225 2.1
+ 4.0202252 2.12 4.0202254 2.14 4.0202256 2.16 4.0202258 2.18 4.020226 2.2 4.0202262 2.22
+ 4.0202264 2.24 4.0202266 2.26 4.0202268 2.28 4.020227 2.3 4.0202272 2.32 4.0202274 2.34
+ 4.0202276 2.36 4.0202278 2.38 4.020228 2.4 4.020229 0 4.03031899 0 4.030318995 3.8
+ 4.030328995 3.8 4.030329 0 6.030329 0 6.03033 -0.2 6.0303302 -0.18 6.0303304 -0.16
+ 6.0303306 -0.14 6.0303308 -0.12 6.030331 -0.1 6.0303312 -0.08 6.0303314 -0.06 6.0303316 -0.04
+ 6.0303318 -0.02 6.030332 0 6.0303322 0.02 6.0303324 0.04 6.0303326 0.06 6.0303328 0.08
+ 6.030333 0.1 6.0303332 0.12 6.0303334 0.14 6.0303336 0.16 6.0303338 0.18 6.030334 0.2
+ 6.0303342 0.22 6.0303344 0.24 6.0303346 0.26 6.0303348 0.28 6.030335 0.3 6.0303352 0.32
+ 6.0303354 0.34 6.0303356 0.36 6.0303358 0.38 6.030336 0.4 6.0303362 0.42 6.0303364 0.44
+ 6.0303366 0.46 6.0303368 0.48 6.030337 0.5 6.0303372 0.52 6.0303374 0.54 6.0303376 0.56
+ 6.0303378 0.58 6.030338 0.6 6.0303382 0.62 6.0303384 0.64 6.0303386 0.66 6.0303388 0.68
+ 6.030339 0.7 6.0303392 0.72 6.0303394 0.74 6.0303396 0.76 6.0303398 0.78 6.03034 0.8
+ 6.0303402 0.82 6.0303404 0.84 6.0303406 0.86 6.0303408 0.88 6.030341 0.9 6.0303412 0.92
+ 6.0303414 0.94 6.0303416 0.96 6.0303418 0.98 6.030342 1 6.0303422 1.02 6.0303424 1.04
+ 6.0303426 1.06 6.0303428 1.08 6.030343 1.1 6.0303432 1.12 6.0303434 1.14 6.0303436 1.16
+ 6.0303438 1.18 6.030344 1.2 6.0303442 1.22 6.0303444 1.24 6.0303446 1.26 6.0303448 1.28
+ 6.030345 1.3 6.0303452 1.32 6.0303454 1.34 6.0303456 1.36 6.0303458 1.38 6.030346 1.4
+ 6.0303462 1.42 6.0303464 1.44 6.0303466 1.46 6.0303468 1.48 6.030347 1.5 6.0303472 1.52
+ 6.0303474 1.54 6.0303476 1.56 6.0303478 1.58 6.030348 1.6 6.0303482 1.62 6.0303484 1.64
+ 6.0303486 1.66 6.0303488 1.68 6.030349 1.7 6.0303492 1.72 6.0303494 1.74 6.0303496 1.76
+ 6.0303498 1.78 6.03035 1.8 6.0303502 1.82 6.0303504 1.84 6.0303506 1.86 6.0303508 1.88
+ 6.030351 1.9 6.0303512 1.92 6.0303514 1.94 6.0303516 1.96 6.0303518 1.98 6.030352 2
+ 6.0303522 2.02 6.0303524 2.04 6.0303526 2.06 6.0303528 2.08 6.030353 2.1 6.0303532 2.12
+ 6.0303534 2.14 6.0303536 2.16 6.0303538 2.18 6.030354 2.2 6.0303542 2.22 6.0303544 2.24
+ 6.0303546 2.26 6.0303548 2.28 6.030355 2.3 6.0303552 2.32 6.0303554 2.34 6.0303556 2.36
+ 6.0303558 2.38 6.030356 2.4 6.030357 0)
Vd18 d18 0 pwl(
+ 0 0 4.0202004 0 4.0202005 0.05 4.0202291 0.05 4.0202292 0 6.0303284 0
+ 6.0303285 0.05 6.0303571 0.05 6.0303572 0)
X18 g18 d18 0 0 fefet_c16
Vg19 g19 0 pwl(
+ 0 0 0.01009099 0 0.010090995 3.9 0.010100995 3.9 0.010101 0 2.02019099 0
+ 2.020190995 -3.9 2.020200995 -3.9 2.020201 0 4.020201 0 4.020202 -0.2 4.0202022 -0.18
+ 4.0202024 -0.16 4.0202026 -0.14 4.0202028 -0.12 4.020203 -0.1 4.0202032 -0.08 4.0202034 -0.06
+ 4.0202036 -0.04 4.0202038 -0.02 4.020204 0 4.0202042 0.02 4.0202044 0.04 4.0202046 0.06
+ 4.0202048 0.08 4.020205 0.1 4.0202052 0.12 4.0202054 0.14 4.0202056 0.16 4.0202058 0.18
+ 4.020206 0.2 4.0202062 0.22 4.0202064 0.24 4.0202066 0.26 4.0202068 0.28 4.020207 0.3
+ 4.0202072 0.32 4.0202074 0.34 4.0202076 0.36 4.0202078 0.38 4.020208 0.4 4.0202082 0.42
+ 4.0202084 0.44 4.0202086 0.46 4.0202088 0.48 4.020209 0.5 4.0202092 0.52 4.0202094 0.54
+ 4.0202096 0.56 4.0202098 0.58 4.02021 0.6 4.0202102 0.62 4.0202104 0.64 4.0202106 0.66
+ 4.0202108 0.68 4.020211 0.7 4.0202112 0.72 4.0202114 0.74 4.0202116 0.76 4.0202118 0.78
+ 4.020212 0.8 4.0202122 0.82 4.0202124 0.84 4.0202126 0.86 4.0202128 0.88 4.020213 0.9
+ 4.0202132 0.92 4.0202134 0.94 4.0202136 0.96 4.0202138 0.98 4.020214 1 4.0202142 1.02
+ 4.0202144 1.04 4.0202146 1.06 4.0202148 1.08 4.020215 1.1 4.0202152 1.12 4.0202154 1.14
+ 4.0202156 1.16 4.0202158 1.18 4.020216 1.2 4.0202162 1.22 4.0202164 1.24 4.0202166 1.26
+ 4.0202168 1.28 4.020217 1.3 4.0202172 1.32 4.0202174 1.34 4.0202176 1.36 4.0202178 1.38
+ 4.020218 1.4 4.0202182 1.42 4.0202184 1.44 4.0202186 1.46 4.0202188 1.48 4.020219 1.5
+ 4.0202192 1.52 4.0202194 1.54 4.0202196 1.56 4.0202198 1.58 4.02022 1.6 4.0202202 1.62
+ 4.0202204 1.64 4.0202206 1.66 4.0202208 1.68 4.020221 1.7 4.0202212 1.72 4.0202214 1.74
+ 4.0202216 1.76 4.0202218 1.78 4.020222 1.8 4.0202222 1.82 4.0202224 1.84 4.0202226 1.86
+ 4.0202228 1.88 4.020223 1.9 4.0202232 1.92 4.0202234 1.94 4.0202236 1.96 4.0202238 1.98
+ 4.020224 2 4.0202242 2.02 4.0202244 2.04 4.0202246 2.06 4.0202248 2.08 4.020225 2.1
+ 4.0202252 2.12 4.0202254 2.14 4.0202256 2.16 4.0202258 2.18 4.020226 2.2 4.0202262 2.22
+ 4.0202264 2.24 4.0202266 2.26 4.0202268 2.28 4.020227 2.3 4.0202272 2.32 4.0202274 2.34
+ 4.0202276 2.36 4.0202278 2.38 4.020228 2.4 4.020229 0 4.03031899 0 4.030318995 3.9
+ 4.030328995 3.9 4.030329 0 6.030329 0 6.03033 -0.2 6.0303302 -0.18 6.0303304 -0.16
+ 6.0303306 -0.14 6.0303308 -0.12 6.030331 -0.1 6.0303312 -0.08 6.0303314 -0.06 6.0303316 -0.04
+ 6.0303318 -0.02 6.030332 0 6.0303322 0.02 6.0303324 0.04 6.0303326 0.06 6.0303328 0.08
+ 6.030333 0.1 6.0303332 0.12 6.0303334 0.14 6.0303336 0.16 6.0303338 0.18 6.030334 0.2
+ 6.0303342 0.22 6.0303344 0.24 6.0303346 0.26 6.0303348 0.28 6.030335 0.3 6.0303352 0.32
+ 6.0303354 0.34 6.0303356 0.36 6.0303358 0.38 6.030336 0.4 6.0303362 0.42 6.0303364 0.44
+ 6.0303366 0.46 6.0303368 0.48 6.030337 0.5 6.0303372 0.52 6.0303374 0.54 6.0303376 0.56
+ 6.0303378 0.58 6.030338 0.6 6.0303382 0.62 6.0303384 0.64 6.0303386 0.66 6.0303388 0.68
+ 6.030339 0.7 6.0303392 0.72 6.0303394 0.74 6.0303396 0.76 6.0303398 0.78 6.03034 0.8
+ 6.0303402 0.82 6.0303404 0.84 6.0303406 0.86 6.0303408 0.88 6.030341 0.9 6.0303412 0.92
+ 6.0303414 0.94 6.0303416 0.96 6.0303418 0.98 6.030342 1 6.0303422 1.02 6.0303424 1.04
+ 6.0303426 1.06 6.0303428 1.08 6.030343 1.1 6.0303432 1.12 6.0303434 1.14 6.0303436 1.16
+ 6.0303438 1.18 6.030344 1.2 6.0303442 1.22 6.0303444 1.24 6.0303446 1.26 6.0303448 1.28
+ 6.030345 1.3 6.0303452 1.32 6.0303454 1.34 6.0303456 1.36 6.0303458 1.38 6.030346 1.4
+ 6.0303462 1.42 6.0303464 1.44 6.0303466 1.46 6.0303468 1.48 6.030347 1.5 6.0303472 1.52
+ 6.0303474 1.54 6.0303476 1.56 6.0303478 1.58 6.030348 1.6 6.0303482 1.62 6.0303484 1.64
+ 6.0303486 1.66 6.0303488 1.68 6.030349 1.7 6.0303492 1.72 6.0303494 1.74 6.0303496 1.76
+ 6.0303498 1.78 6.03035 1.8 6.0303502 1.82 6.0303504 1.84 6.0303506 1.86 6.0303508 1.88
+ 6.030351 1.9 6.0303512 1.92 6.0303514 1.94 6.0303516 1.96 6.0303518 1.98 6.030352 2
+ 6.0303522 2.02 6.0303524 2.04 6.0303526 2.06 6.0303528 2.08 6.030353 2.1 6.0303532 2.12
+ 6.0303534 2.14 6.0303536 2.16 6.0303538 2.18 6.030354 2.2 6.0303542 2.22 6.0303544 2.24
+ 6.0303546 2.26 6.0303548 2.28 6.030355 2.3 6.0303552 2.32 6.0303554 2.34 6.0303556 2.36
+ 6.0303558 2.38 6.030356 2.4 6.030357 0)
Vd19 d19 0 pwl(
+ 0 0 4.0202004 0 4.0202005 0.05 4.0202291 0.05 4.0202292 0 6.0303284 0
+ 6.0303285 0.05 6.0303571 0.05 6.0303572 0)
X19 g19 d19 0 0 fefet_c16
Vg20 g20 0 pwl(
+ 0 0 0.01009099 0 0.010090995 4 0.010100995 4 0.010101 0 2.02019099 0
+ 2.020190995 -4 2.020200995 -4 2.020201 0 4.020201 0 4.020202 -0.2 4.0202022 -0.18
+ 4.0202024 -0.16 4.0202026 -0.14 4.0202028 -0.12 4.020203 -0.1 4.0202032 -0.08 4.0202034 -0.06
+ 4.0202036 -0.04 4.0202038 -0.02 4.020204 0 4.0202042 0.02 4.0202044 0.04 4.0202046 0.06
+ 4.0202048 0.08 4.020205 0.1 4.0202052 0.12 4.0202054 0.14 4.0202056 0.16 4.0202058 0.18
+ 4.020206 0.2 4.0202062 0.22 4.0202064 0.24 4.0202066 0.26 4.0202068 0.28 4.020207 0.3
+ 4.0202072 0.32 4.0202074 0.34 4.0202076 0.36 4.0202078 0.38 4.020208 0.4 4.0202082 0.42
+ 4.0202084 0.44 4.0202086 0.46 4.0202088 0.48 4.020209 0.5 4.0202092 0.52 4.0202094 0.54
+ 4.0202096 0.56 4.0202098 0.58 4.02021 0.6 4.0202102 0.62 4.0202104 0.64 4.0202106 0.66
+ 4.0202108 0.68 4.020211 0.7 4.0202112 0.72 4.0202114 0.74 4.0202116 0.76 4.0202118 0.78
+ 4.020212 0.8 4.0202122 0.82 4.0202124 0.84 4.0202126 0.86 4.0202128 0.88 4.020213 0.9
+ 4.0202132 0.92 4.0202134 0.94 4.0202136 0.96 4.0202138 0.98 4.020214 1 4.0202142 1.02
+ 4.0202144 1.04 4.0202146 1.06 4.0202148 1.08 4.020215 1.1 4.0202152 1.12 4.0202154 1.14
+ 4.0202156 1.16 4.0202158 1.18 4.020216 1.2 4.0202162 1.22 4.0202164 1.24 4.0202166 1.26
+ 4.0202168 1.28 4.020217 1.3 4.0202172 1.32 4.0202174 1.34 4.0202176 1.36 4.0202178 1.38
+ 4.020218 1.4 4.0202182 1.42 4.0202184 1.44 4.0202186 1.46 4.0202188 1.48 4.020219 1.5
+ 4.0202192 1.52 4.0202194 1.54 4.0202196 1.56 4.0202198 1.58 4.02022 1.6 4.0202202 1.62
+ 4.0202204 1.64 4.0202206 1.66 4.0202208 1.68 4.020221 1.7 4.0202212 1.72 4.0202214 1.74
+ 4.0202216 1.76 4.0202218 1.78 4.020222 1.8 4.0202222 1.82 4.0202224 1.84 4.0202226 1.86
+ 4.0202228 1.88 4.020223 1.9 4.0202232 1.92 4.0202234 1.94 4.0202236 1.96 4.0202238 1.98
+ 4.020224 2 4.0202242 2.02 4.0202244 2.04 4.0202246 2.06 4.0202248 2.08 4.020225 2.1
+ 4.0202252 2.12 4.0202254 2.14 4.0202256 2.16 4.0202258 2.18 4.020226 2.2 4.0202262 2.22
+ 4.0202264 2.24 4.0202266 2.26 4.0202268 2.28 4.020227 2.3 4.0202272 2.32 4.0202274 2.34
+ 4.0202276 2.36 4.0202278 2.38 4.020228 2.4 4.020229 0 4.03031899 0 4.030318995 4
+ 4.030328995 4 4.030329 0 6.030329 0 6.03033 -0.2 6.0303302 -0.18 6.0303304 -0.16
+ 6.0303306 -0.14 6.0303308 -0.12 6.030331 -0.1 6.0303312 -0.08 6.0303314 -0.06 6.0303316 -0.04
+ 6.0303318 -0.02 6.030332 0 6.0303322 0.02 6.0303324 0.04 6.0303326 0.06 6.0303328 0.08
+ 6.030333 0.1 6.0303332 0.12 6.0303334 0.14 6.0303336 0.16 6.0303338 0.18 6.030334 0.2
+ 6.0303342 0.22 6.0303344 0.24 6.0303346 0.26 6.0303348 0.28 6.030335 0.3 6.0303352 0.32
+ 6.0303354 0.34 6.0303356 0.36 6.0303358 0.38 6.030336 0.4 6.0303362 0.42 6.0303364 0.44
+ 6.0303366 0.46 6.0303368 0.48 6.030337 0.5 6.0303372 0.52 6.0303374 0.54 6.0303376 0.56
+ 6.0303378 0.58 6.030338 0.6 6.0303382 0.62 6.0303384 0.64 6.0303386 0.66 6.0303388 0.68
+ 6.030339 0.7 6.0303392 0.72 6.0303394 0.74 6.0303396 0.76 6.0303398 0.78 6.03034 0.8
+ 6.0303402 0.82 6.0303404 0.84 6.0303406 0.86 6.0303408 0.88 6.030341 0.9 6.0303412 0.92
+ 6.0303414 0.94 6.0303416 0.96 6.0303418 0.98 6.030342 1 6.0303422 1.02 6.0303424 1.04
+ 6.0303426 1.06 6.0303428 1.08 6.030343 1.1 6.0303432 1.12 6.0303434 1.14 6.0303436 1.16
+ 6.0303438 1.18 6.030344 1.2 6.0303442 1.22 6.0303444 1.24 6.0303446 1.26 6.0303448 1.28
+ 6.030345 1.3 6.0303452 1.32 6.0303454 1.34 6.0303456 1.36 6.0303458 1.38 6.030346 1.4
+ 6.0303462 1.42 6.0303464 1.44 6.0303466 1.46 6.0303468 1.48 6.030347 1.5 6.0303472 1.52
+ 6.0303474 1.54 6.0303476 1.56 6.0303478 1.58 6.030348 1.6 6.0303482 1.62 6.0303484 1.64
+ 6.0303486 1.66 6.0303488 1.68 6.030349 1.7 6.0303492 1.72 6.0303494 1.74 6.0303496 1.76
+ 6.0303498 1.78 6.03035 1.8 6.0303502 1.82 6.0303504 1.84 6.0303506 1.86 6.0303508 1.88
+ 6.030351 1.9 6.0303512 1.92 6.0303514 1.94 6.0303516 1.96 6.0303518 1.98 6.030352 2
+ 6.0303522 2.02 6.0303524 2.04 6.0303526 2.06 6.0303528 2.08 6.030353 2.1 6.0303532 2.12
+ 6.0303534 2.14 6.0303536 2.16 6.0303538 2.18 6.030354 2.2 6.0303542 2.22 6.0303544 2.24
+ 6.0303546 2.26 6.0303548 2.28 6.030355 2.3 6.0303552 2.32 6.0303554 2.34 6.0303556 2.36
+ 6.0303558 2.38 6.030356 2.4 6.030357 0)
Vd20 d20 0 pwl(
+ 0 0 4.0202004 0 4.0202005 0.05 4.0202291 0.05 4.0202292 0 6.0303284 0
+ 6.0303285 0.05 6.0303571 0.05 6.0303572 0)
X20 g20 d20 0 0 fefet_c16
Vg21 g21 0 pwl(
+ 0 0 0.01009099 0 0.010090995 4.1 0.010100995 4.1 0.010101 0 2.02019099 0
+ 2.020190995 -4.1 2.020200995 -4.1 2.020201 0 4.020201 0 4.020202 -0.2 4.0202022 -0.18
+ 4.0202024 -0.16 4.0202026 -0.14 4.0202028 -0.12 4.020203 -0.1 4.0202032 -0.08 4.0202034 -0.06
+ 4.0202036 -0.04 4.0202038 -0.02 4.020204 0 4.0202042 0.02 4.0202044 0.04 4.0202046 0.06
+ 4.0202048 0.08 4.020205 0.1 4.0202052 0.12 4.0202054 0.14 4.0202056 0.16 4.0202058 0.18
+ 4.020206 0.2 4.0202062 0.22 4.0202064 0.24 4.0202066 0.26 4.0202068 0.28 4.020207 0.3
+ 4.0202072 0.32 4.0202074 0.34 4.0202076 0.36 4.0202078 0.38 4.020208 0.4 4.0202082 0.42
+ 4.0202084 0.44 4.0202086 0.46 4.0202088 0.48 4.020209 0.5 4.0202092 0.52 4.0202094 0.54
+ 4.0202096 0.56 4.0202098 0.58 4.02021 0.6 4.0202102 0.62 4.0202104 0.64 4.0202106 0.66
+ 4.0202108 0.68 4.020211 0.7 4.0202112 0.72 4.0202114 0.74 4.0202116 0.76 4.0202118 0.78
+ 4.020212 0.8 4.0202122 0.82 4.0202124 0.84 4.0202126 0.86 4.0202128 0.88 4.020213 0.9
+ 4.0202132 0.92 4.0202134 0.94 4.0202136 0.96 4.0202138 0.98 4.020214 1 4.0202142 1.02
+ 4.0202144 1.04 4.0202146 1.06 4.0202148 1.08 4.020215 1.1 4.0202152 1.12 4.0202154 1.14
+ 4.0202156 1.16 4.0202158 1.18 4.020216 1.2 4.0202162 1.22 4.0202164 1.24 4.0202166 1.26
+ 4.0202168 1.28 4.020217 1.3 4.0202172 1.32 4.0202174 1.34 4.0202176 1.36 4.0202178 1.38
+ 4.020218 1.4 4.0202182 1.42 4.0202184 1.44 4.0202186 1.46 4.0202188 1.48 4.020219 1.5
+ 4.0202192 1.52 4.0202194 1.54 4.0202196 1.56 4.0202198 1.58 4.02022 1.6 4.0202202 1.62
+ 4.0202204 1.64 4.0202206 1.66 4.0202208 1.68 4.020221 1.7 4.0202212 1.72 4.0202214 1.74
+ 4.0202216 1.76 4.0202218 1.78 4.020222 1.8 4.0202222 1.82 4.0202224 1.84 4.0202226 1.86
+ 4.0202228 1.88 4.020223 1.9 4.0202232 1.92 4.0202234 1.94 4.0202236 1.96 4.0202238 1.98
+ 4.020224 2 4.0202242 2.02 4.0202244 2.04 4.0202246 2.06 4.0202248 2.08 4.020225 2.1
+ 4.0202252 2.12 4.0202254 2.14 4.0202256 2.16 4.0202258 2.18 4.020226 2.2 4.0202262 2.22
+ 4.0202264 2.24 4.0202266 2.26 4.0202268 2.28 4.020227 2.3 4.0202272 2.32 4.0202274 2.34
+ 4.0202276 2.36 4.0202278 2.38 4.020228 2.4 4.020229 0 4.03031899 0 4.030318995 4.1
+ 4.030328995 4.1 4.030329 0 6.030329 0 6.03033 -0.2 6.0303302 -0.18 6.0303304 -0.16
+ 6.0303306 -0.14 6.0303308 -0.12 6.030331 -0.1 6.0303312 -0.08 6.0303314 -0.06 6.0303316 -0.04
+ 6.0303318 -0.02 6.030332 0 6.0303322 0.02 6.0303324 0.04 6.0303326 0.06 6.0303328 0.08
+ 6.030333 0.1 6.0303332 0.12 6.0303334 0.14 6.0303336 0.16 6.0303338 0.18 6.030334 0.2
+ 6.0303342 0.22 6.0303344 0.24 6.0303346 0.26 6.0303348 0.28 6.030335 0.3 6.0303352 0.32
+ 6.0303354 0.34 6.0303356 0.36 6.0303358 0.38 6.030336 0.4 6.0303362 0.42 6.0303364 0.44
+ 6.0303366 0.46 6.0303368 0.48 6.030337 0.5 6.0303372 0.52 6.0303374 0.54 6.0303376 0.56
+ 6.0303378 0.58 6.030338 0.6 6.0303382 0.62 6.0303384 0.64 6.0303386 0.66 6.0303388 0.68
+ 6.030339 0.7 6.0303392 0.72 6.0303394 0.74 6.0303396 0.76 6.0303398 0.78 6.03034 0.8
+ 6.0303402 0.82 6.0303404 0.84 6.0303406 0.86 6.0303408 0.88 6.030341 0.9 6.0303412 0.92
+ 6.0303414 0.94 6.0303416 0.96 6.0303418 0.98 6.030342 1 6.0303422 1.02 6.0303424 1.04
+ 6.0303426 1.06 6.0303428 1.08 6.030343 1.1 6.0303432 1.12 6.0303434 1.14 6.0303436 1.16
+ 6.0303438 1.18 6.030344 1.2 6.0303442 1.22 6.0303444 1.24 6.0303446 1.26 6.0303448 1.28
+ 6.030345 1.3 6.0303452 1.32 6.0303454 1.34 6.0303456 1.36 6.0303458 1.38 6.030346 1.4
+ 6.0303462 1.42 6.0303464 1.44 6.0303466 1.46 6.0303468 1.48 6.030347 1.5 6.0303472 1.52
+ 6.0303474 1.54 6.0303476 1.56 6.0303478 1.58 6.030348 1.6 6.0303482 1.62 6.0303484 1.64
+ 6.0303486 1.66 6.0303488 1.68 6.030349 1.7 6.0303492 1.72 6.0303494 1.74 6.0303496 1.76
+ 6.0303498 1.78 6.03035 1.8 6.0303502 1.82 6.0303504 1.84 6.0303506 1.86 6.0303508 1.88
+ 6.030351 1.9 6.0303512 1.92 6.0303514 1.94 6.0303516 1.96 6.0303518 1.98 6.030352 2
+ 6.0303522 2.02 6.0303524 2.04 6.0303526 2.06 6.0303528 2.08 6.030353 2.1 6.0303532 2.12
+ 6.0303534 2.14 6.0303536 2.16 6.0303538 2.18 6.030354 2.2 6.0303542 2.22 6.0303544 2.24
+ 6.0303546 2.26 6.0303548 2.28 6.030355 2.3 6.0303552 2.32 6.0303554 2.34 6.0303556 2.36
+ 6.0303558 2.38 6.030356 2.4 6.030357 0)
Vd21 d21 0 pwl(
+ 0 0 4.0202004 0 4.0202005 0.05 4.0202291 0.05 4.0202292 0 6.0303284 0
+ 6.0303285 0.05 6.0303571 0.05 6.0303572 0)
X21 g21 d21 0 0 fefet_c16
Vg22 g22 0 pwl(
+ 0 0 0.01009099 0 0.010090995 4.2 0.010100995 4.2 0.010101 0 2.02019099 0
+ 2.020190995 -4.2 2.020200995 -4.2 2.020201 0 4.020201 0 4.020202 -0.2 4.0202022 -0.18
+ 4.0202024 -0.16 4.0202026 -0.14 4.0202028 -0.12 4.020203 -0.1 4.0202032 -0.08 4.0202034 -0.06
+ 4.0202036 -0.04 4.0202038 -0.02 4.020204 0 4.0202042 0.02 4.0202044 0.04 4.0202046 0.06
+ 4.0202048 0.08 4.020205 0.1 4.0202052 0.12 4.0202054 0.14 4.0202056 0.16 4.0202058 0.18
+ 4.020206 0.2 4.0202062 0.22 4.0202064 0.24 4.0202066 0.26 4.0202068 0.28 4.020207 0.3
+ 4.0202072 0.32 4.0202074 0.34 4.0202076 0.36 4.0202078 0.38 4.020208 0.4 4.0202082 0.42
+ 4.0202084 0.44 4.0202086 0.46 4.0202088 0.48 4.020209 0.5 4.0202092 0.52 4.0202094 0.54
+ 4.0202096 0.56 4.0202098 0.58 4.02021 0.6 4.0202102 0.62 4.0202104 0.64 4.0202106 0.66
+ 4.0202108 0.68 4.020211 0.7 4.0202112 0.72 4.0202114 0.74 4.0202116 0.76 4.0202118 0.78
+ 4.020212 0.8 4.0202122 0.82 4.0202124 0.84 4.0202126 0.86 4.0202128 0.88 4.020213 0.9
+ 4.0202132 0.92 4.0202134 0.94 4.0202136 0.96 4.0202138 0.98 4.020214 1 4.0202142 1.02
+ 4.0202144 1.04 4.0202146 1.06 4.0202148 1.08 4.020215 1.1 4.0202152 1.12 4.0202154 1.14
+ 4.0202156 1.16 4.0202158 1.18 4.020216 1.2 4.0202162 1.22 4.0202164 1.24 4.0202166 1.26
+ 4.0202168 1.28 4.020217 1.3 4.0202172 1.32 4.0202174 1.34 4.0202176 1.36 4.0202178 1.38
+ 4.020218 1.4 4.0202182 1.42 4.0202184 1.44 4.0202186 1.46 4.0202188 1.48 4.020219 1.5
+ 4.0202192 1.52 4.0202194 1.54 4.0202196 1.56 4.0202198 1.58 4.02022 1.6 4.0202202 1.62
+ 4.0202204 1.64 4.0202206 1.66 4.0202208 1.68 4.020221 1.7 4.0202212 1.72 4.0202214 1.74
+ 4.0202216 1.76 4.0202218 1.78 4.020222 1.8 4.0202222 1.82 4.0202224 1.84 4.0202226 1.86
+ 4.0202228 1.88 4.020223 1.9 4.0202232 1.92 4.0202234 1.94 4.0202236 1.96 4.0202238 1.98
+ 4.020224 2 4.0202242 2.02 4.0202244 2.04 4.0202246 2.06 4.0202248 2.08 4.020225 2.1
+ 4.0202252 2.12 4.0202254 2.14 4.0202256 2.16 4.0202258 2.18 4.020226 2.2 4.0202262 2.22
+ 4.0202264 2.24 4.0202266 2.26 4.0202268 2.28 4.020227 2.3 4.0202272 2.32 4.0202274 2.34
+ 4.0202276 2.36 4.0202278 2.38 4.020228 2.4 4.020229 0 4.03031899 0 4.030318995 4.2
+ 4.030328995 4.2 4.030329 0 6.030329 0 6.03033 -0.2 6.0303302 -0.18 6.0303304 -0.16
+ 6.0303306 -0.14 6.0303308 -0.12 6.030331 -0.1 6.0303312 -0.08 6.0303314 -0.06 6.0303316 -0.04
+ 6.0303318 -0.02 6.030332 0 6.0303322 0.02 6.0303324 0.04 6.0303326 0.06 6.0303328 0.08
+ 6.030333 0.1 6.0303332 0.12 6.0303334 0.14 6.0303336 0.16 6.0303338 0.18 6.030334 0.2
+ 6.0303342 0.22 6.0303344 0.24 6.0303346 0.26 6.0303348 0.28 6.030335 0.3 6.0303352 0.32
+ 6.0303354 0.34 6.0303356 0.36 6.0303358 0.38 6.030336 0.4 6.0303362 0.42 6.0303364 0.44
+ 6.0303366 0.46 6.0303368 0.48 6.030337 0.5 6.0303372 0.52 6.0303374 0.54 6.0303376 0.56
+ 6.0303378 0.58 6.030338 0.6 6.0303382 0.62 6.0303384 0.64 6.0303386 0.66 6.0303388 0.68
+ 6.030339 0.7 6.0303392 0.72 6.0303394 0.74 6.0303396 0.76 6.0303398 0.78 6.03034 0.8
+ 6.0303402 0.82 6.0303404 0.84 6.0303406 0.86 6.0303408 0.88 6.030341 0.9 6.0303412 0.92
+ 6.0303414 0.94 6.0303416 0.96 6.0303418 0.98 6.030342 1 6.0303422 1.02 6.0303424 1.04
+ 6.0303426 1.06 6.0303428 1.08 6.030343 1.1 6.0303432 1.12 6.0303434 1.14 6.0303436 1.16
+ 6.0303438 1.18 6.030344 1.2 6.0303442 1.22 6.0303444 1.24 6.0303446 1.26 6.0303448 1.28
+ 6.030345 1.3 6.0303452 1.32 6.0303454 1.34 6.0303456 1.36 6.0303458 1.38 6.030346 1.4
+ 6.0303462 1.42 6.0303464 1.44 6.0303466 1.46 6.0303468 1.48 6.030347 1.5 6.0303472 1.52
+ 6.0303474 1.54 6.0303476 1.56 6.0303478 1.58 6.030348 1.6 6.0303482 1.62 6.0303484 1.64
+ 6.0303486 1.66 6.0303488 1.68 6.030349 1.7 6.0303492 1.72 6.0303494 1.74 6.0303496 1.76
+ 6.0303498 1.78 6.03035 1.8 6.0303502 1.82 6.0303504 1.84 6.0303506 1.86 6.0303508 1.88
+ 6.030351 1.9 6.0303512 1.92 6.0303514 1.94 6.0303516 1.96 6.0303518 1.98 6.030352 2
+ 6.0303522 2.02 6.0303524 2.04 6.0303526 2.06 6.0303528 2.08 6.030353 2.1 6.0303532 2.12
+ 6.0303534 2.14 6.0303536 2.16 6.0303538 2.18 6.030354 2.2 6.0303542 2.22 6.0303544 2.24
+ 6.0303546 2.26 6.0303548 2.28 6.030355 2.3 6.0303552 2.32 6.0303554 2.34 6.0303556 2.36
+ 6.0303558 2.38 6.030356 2.4 6.030357 0)
Vd22 d22 0 pwl(
+ 0 0 4.0202004 0 4.0202005 0.05 4.0202291 0.05 4.0202292 0 6.0303284 0
+ 6.0303285 0.05 6.0303571 0.05 6.0303572 0)
X22 g22 d22 0 0 fefet_c16
Vg23 g23 0 pwl(
+ 0 0 0.01009099 0 0.010090995 4.3 0.010100995 4.3 0.010101 0 2.02019099 0
+ 2.020190995 -4.3 2.020200995 -4.3 2.020201 0 4.020201 0 4.020202 -0.2 4.0202022 -0.18
+ 4.0202024 -0.16 4.0202026 -0.14 4.0202028 -0.12 4.020203 -0.1 4.0202032 -0.08 4.0202034 -0.06
+ 4.0202036 -0.04 4.0202038 -0.02 4.020204 0 4.0202042 0.02 4.0202044 0.04 4.0202046 0.06
+ 4.0202048 0.08 4.020205 0.1 4.0202052 0.12 4.0202054 0.14 4.0202056 0.16 4.0202058 0.18
+ 4.020206 0.2 4.0202062 0.22 4.0202064 0.24 4.0202066 0.26 4.0202068 0.28 4.020207 0.3
+ 4.0202072 0.32 4.0202074 0.34 4.0202076 0.36 4.0202078 0.38 4.020208 0.4 4.0202082 0.42
+ 4.0202084 0.44 4.0202086 0.46 4.0202088 0.48 4.020209 0.5 4.0202092 0.52 4.0202094 0.54
+ 4.0202096 0.56 4.0202098 0.58 4.02021 0.6 4.0202102 0.62 4.0202104 0.64 4.0202106 0.66
+ 4.0202108 0.68 4.020211 0.7 4.0202112 0.72 4.0202114 0.74 4.0202116 0.76 4.0202118 0.78
+ 4.020212 0.8 4.0202122 0.82 4.0202124 0.84 4.0202126 0.86 4.0202128 0.88 4.020213 0.9
+ 4.0202132 0.92 4.0202134 0.94 4.0202136 0.96 4.0202138 0.98 4.020214 1 4.0202142 1.02
+ 4.0202144 1.04 4.0202146 1.06 4.0202148 1.08 4.020215 1.1 4.0202152 1.12 4.0202154 1.14
+ 4.0202156 1.16 4.0202158 1.18 4.020216 1.2 4.0202162 1.22 4.0202164 1.24 4.0202166 1.26
+ 4.0202168 1.28 4.020217 1.3 4.0202172 1.32 4.0202174 1.34 4.0202176 1.36 4.0202178 1.38
+ 4.020218 1.4 4.0202182 1.42 4.0202184 1.44 4.0202186 1.46 4.0202188 1.48 4.020219 1.5
+ 4.0202192 1.52 4.0202194 1.54 4.0202196 1.56 4.0202198 1.58 4.02022 1.6 4.0202202 1.62
+ 4.0202204 1.64 4.0202206 1.66 4.0202208 1.68 4.020221 1.7 4.0202212 1.72 4.0202214 1.74
+ 4.0202216 1.76 4.0202218 1.78 4.020222 1.8 4.0202222 1.82 4.0202224 1.84 4.0202226 1.86
+ 4.0202228 1.88 4.020223 1.9 4.0202232 1.92 4.0202234 1.94 4.0202236 1.96 4.0202238 1.98
+ 4.020224 2 4.0202242 2.02 4.0202244 2.04 4.0202246 2.06 4.0202248 2.08 4.020225 2.1
+ 4.0202252 2.12 4.0202254 2.14 4.0202256 2.16 4.0202258 2.18 4.020226 2.2 4.0202262 2.22
+ 4.0202264 2.24 4.0202266 2.26 4.0202268 2.28 4.020227 2.3 4.0202272 2.32 4.0202274 2.34
+ 4.0202276 2.36 4.0202278 2.38 4.020228 2.4 4.020229 0 4.03031899 0 4.030318995 4.3
+ 4.030328995 4.3 4.030329 0 6.030329 0 6.03033 -0.2 6.0303302 -0.18 6.0303304 -0.16
+ 6.0303306 -0.14 6.0303308 -0.12 6.030331 -0.1 6.0303312 -0.08 6.0303314 -0.06 6.0303316 -0.04
+ 6.0303318 -0.02 6.030332 0 6.0303322 0.02 6.0303324 0.04 6.0303326 0.06 6.0303328 0.08
+ 6.030333 0.1 6.0303332 0.12 6.0303334 0.14 6.0303336 0.16 6.0303338 0.18 6.030334 0.2
+ 6.0303342 0.22 6.0303344 0.24 6.0303346 0.26 6.0303348 0.28 6.030335 0.3 6.0303352 0.32
+ 6.0303354 0.34 6.0303356 0.36 6.0303358 0.38 6.030336 0.4 6.0303362 0.42 6.0303364 0.44
+ 6.0303366 0.46 6.0303368 0.48 6.030337 0.5 6.0303372 0.52 6.0303374 0.54 6.0303376 0.56
+ 6.0303378 0.58 6.030338 0.6 6.0303382 0.62 6.0303384 0.64 6.0303386 0.66 6.0303388 0.68
+ 6.030339 0.7 6.0303392 0.72 6.0303394 0.74 6.0303396 0.76 6.0303398 0.78 6.03034 0.8
+ 6.0303402 0.82 6.0303404 0.84 6.0303406 0.86 6.0303408 0.88 6.030341 0.9 6.0303412 0.92
+ 6.0303414 0.94 6.0303416 0.96 6.0303418 0.98 6.030342 1 6.0303422 1.02 6.0303424 1.04
+ 6.0303426 1.06 6.0303428 1.08 6.030343 1.1 6.0303432 1.12 6.0303434 1.14 6.0303436 1.16
+ 6.0303438 1.18 6.030344 1.2 6.0303442 1.22 6.0303444 1.24 6.0303446 1.26 6.0303448 1.28
+ 6.030345 1.3 6.0303452 1.32 6.0303454 1.34 6.0303456 1.36 6.0303458 1.38 6.030346 1.4
+ 6.0303462 1.42 6.0303464 1.44 6.0303466 1.46 6.0303468 1.48 6.030347 1.5 6.0303472 1.52
+ 6.0303474 1.54 6.0303476 1.56 6.0303478 1.58 6.030348 1.6 6.0303482 1.62 6.0303484 1.64
+ 6.0303486 1.66 6.0303488 1.68 6.030349 1.7 6.0303492 1.72 6.0303494 1.74 6.0303496 1.76
+ 6.0303498 1.78 6.03035 1.8 6.0303502 1.82 6.0303504 1.84 6.0303506 1.86 6.0303508 1.88
+ 6.030351 1.9 6.0303512 1.92 6.0303514 1.94 6.0303516 1.96 6.0303518 1.98 6.030352 2
+ 6.0303522 2.02 6.0303524 2.04 6.0303526 2.06 6.0303528 2.08 6.030353 2.1 6.0303532 2.12
+ 6.0303534 2.14 6.0303536 2.16 6.0303538 2.18 6.030354 2.2 6.0303542 2.22 6.0303544 2.24
+ 6.0303546 2.26 6.0303548 2.28 6.030355 2.3 6.0303552 2.32 6.0303554 2.34 6.0303556 2.36
+ 6.0303558 2.38 6.030356 2.4 6.030357 0)
Vd23 d23 0 pwl(
+ 0 0 4.0202004 0 4.0202005 0.05 4.0202291 0.05 4.0202292 0 6.0303284 0
+ 6.0303285 0.05 6.0303571 0.05 6.0303572 0)
X23 g23 d23 0 0 fefet_c16
Vg24 g24 0 pwl(
+ 0 0 0.01009099 0 0.010090995 4.4 0.010100995 4.4 0.010101 0 2.02019099 0
+ 2.020190995 -4.4 2.020200995 -4.4 2.020201 0 4.020201 0 4.020202 -0.2 4.0202022 -0.18
+ 4.0202024 -0.16 4.0202026 -0.14 4.0202028 -0.12 4.020203 -0.1 4.0202032 -0.08 4.0202034 -0.06
+ 4.0202036 -0.04 4.0202038 -0.02 4.020204 0 4.0202042 0.02 4.0202044 0.04 4.0202046 0.06
+ 4.0202048 0.08 4.020205 0.1 4.0202052 0.12 4.0202054 0.14 4.0202056 0.16 4.0202058 0.18
+ 4.020206 0.2 4.0202062 0.22 4.0202064 0.24 4.0202066 0.26 4.0202068 0.28 4.020207 0.3
+ 4.0202072 0.32 4.0202074 0.34 4.0202076 0.36 4.0202078 0.38 4.020208 0.4 4.0202082 0.42
+ 4.0202084 0.44 4.0202086 0.46 4.0202088 0.48 4.020209 0.5 4.0202092 0.52 4.0202094 0.54
+ 4.0202096 0.56 4.0202098 0.58 4.02021 0.6 4.0202102 0.62 4.0202104 0.64 4.0202106 0.66
+ 4.0202108 0.68 4.020211 0.7 4.0202112 0.72 4.0202114 0.74 4.0202116 0.76 4.0202118 0.78
+ 4.020212 0.8 4.0202122 0.82 4.0202124 0.84 4.0202126 0.86 4.0202128 0.88 4.020213 0.9
+ 4.0202132 0.92 4.0202134 0.94 4.0202136 0.96 4.0202138 0.98 4.020214 1 4.0202142 1.02
+ 4.0202144 1.04 4.0202146 1.06 4.0202148 1.08 4.020215 1.1 4.0202152 1.12 4.0202154 1.14
+ 4.0202156 1.16 4.0202158 1.18 4.020216 1.2 4.0202162 1.22 4.0202164 1.24 4.0202166 1.26
+ 4.0202168 1.28 4.020217 1.3 4.0202172 1.32 4.0202174 1.34 4.0202176 1.36 4.0202178 1.38
+ 4.020218 1.4 4.0202182 1.42 4.0202184 1.44 4.0202186 1.46 4.0202188 1.48 4.020219 1.5
+ 4.0202192 1.52 4.0202194 1.54 4.0202196 1.56 4.0202198 1.58 4.02022 1.6 4.0202202 1.62
+ 4.0202204 1.64 4.0202206 1.66 4.0202208 1.68 4.020221 1.7 4.0202212 1.72 4.0202214 1.74
+ 4.0202216 1.76 4.0202218 1.78 4.020222 1.8 4.0202222 1.82 4.0202224 1.84 4.0202226 1.86
+ 4.0202228 1.88 4.020223 1.9 4.0202232 1.92 4.0202234 1.94 4.0202236 1.96 4.0202238 1.98
+ 4.020224 2 4.0202242 2.02 4.0202244 2.04 4.0202246 2.06 4.0202248 2.08 4.020225 2.1
+ 4.0202252 2.12 4.0202254 2.14 4.0202256 2.16 4.0202258 2.18 4.020226 2.2 4.0202262 2.22
+ 4.0202264 2.24 4.0202266 2.26 4.0202268 2.28 4.020227 2.3 4.0202272 2.32 4.0202274 2.34
+ 4.0202276 2.36 4.0202278 2.38 4.020228 2.4 4.020229 0 4.03031899 0 4.030318995 4.4
+ 4.030328995 4.4 4.030329 0 6.030329 0 6.03033 -0.2 6.0303302 -0.18 6.0303304 -0.16
+ 6.0303306 -0.14 6.0303308 -0.12 6.030331 -0.1 6.0303312 -0.08 6.0303314 -0.06 6.0303316 -0.04
+ 6.0303318 -0.02 6.030332 0 6.0303322 0.02 6.0303324 0.04 6.0303326 0.06 6.0303328 0.08
+ 6.030333 0.1 6.0303332 0.12 6.0303334 0.14 6.0303336 0.16 6.0303338 0.18 6.030334 0.2
+ 6.0303342 0.22 6.0303344 0.24 6.0303346 0.26 6.0303348 0.28 6.030335 0.3 6.0303352 0.32
+ 6.0303354 0.34 6.0303356 0.36 6.0303358 0.38 6.030336 0.4 6.0303362 0.42 6.0303364 0.44
+ 6.0303366 0.46 6.0303368 0.48 6.030337 0.5 6.0303372 0.52 6.0303374 0.54 6.0303376 0.56
+ 6.0303378 0.58 6.030338 0.6 6.0303382 0.62 6.0303384 0.64 6.0303386 0.66 6.0303388 0.68
+ 6.030339 0.7 6.0303392 0.72 6.0303394 0.74 6.0303396 0.76 6.0303398 0.78 6.03034 0.8
+ 6.0303402 0.82 6.0303404 0.84 6.0303406 0.86 6.0303408 0.88 6.030341 0.9 6.0303412 0.92
+ 6.0303414 0.94 6.0303416 0.96 6.0303418 0.98 6.030342 1 6.0303422 1.02 6.0303424 1.04
+ 6.0303426 1.06 6.0303428 1.08 6.030343 1.1 6.0303432 1.12 6.0303434 1.14 6.0303436 1.16
+ 6.0303438 1.18 6.030344 1.2 6.0303442 1.22 6.0303444 1.24 6.0303446 1.26 6.0303448 1.28
+ 6.030345 1.3 6.0303452 1.32 6.0303454 1.34 6.0303456 1.36 6.0303458 1.38 6.030346 1.4
+ 6.0303462 1.42 6.0303464 1.44 6.0303466 1.46 6.0303468 1.48 6.030347 1.5 6.0303472 1.52
+ 6.0303474 1.54 6.0303476 1.56 6.0303478 1.58 6.030348 1.6 6.0303482 1.62 6.0303484 1.64
+ 6.0303486 1.66 6.0303488 1.68 6.030349 1.7 6.0303492 1.72 6.0303494 1.74 6.0303496 1.76
+ 6.0303498 1.78 6.03035 1.8 6.0303502 1.82 6.0303504 1.84 6.0303506 1.86 6.0303508 1.88
+ 6.030351 1.9 6.0303512 1.92 6.0303514 1.94 6.0303516 1.96 6.0303518 1.98 6.030352 2
+ 6.0303522 2.02 6.0303524 2.04 6.0303526 2.06 6.0303528 2.08 6.030353 2.1 6.0303532 2.12
+ 6.0303534 2.14 6.0303536 2.16 6.0303538 2.18 6.030354 2.2 6.0303542 2.22 6.0303544 2.24
+ 6.0303546 2.26 6.0303548 2.28 6.030355 2.3 6.0303552 2.32 6.0303554 2.34 6.0303556 2.36
+ 6.0303558 2.38 6.030356 2.4 6.030357 0)
Vd24 d24 0 pwl(
+ 0 0 4.0202004 0 4.0202005 0.05 4.0202291 0.05 4.0202292 0 6.0303284 0
+ 6.0303285 0.05 6.0303571 0.05 6.0303572 0)
X24 g24 d24 0 0 fefet_c16
.control
set wr_singlescale
set wr_vecnames
tran 1n 6.030358 0 0.0301518 uic
wrdata sim/out/t1f/t1f_w01.csv v(g0) i(vd0) v(g1) i(vd1) v(g2) i(vd2) v(g3) i(vd3)
+ v(g4) i(vd4) v(g5) i(vd5) v(g6) i(vd6) v(g7) i(vd7)
+ v(g8) i(vd8) v(g9) i(vd9) v(g10) i(vd10) v(g11) i(vd11)
+ v(g12) i(vd12) v(g13) i(vd13) v(g14) i(vd14) v(g15) i(vd15)
+ v(g16) i(vd16) v(g17) i(vd17) v(g18) i(vd18) v(g19) i(vd19)
+ v(g20) i(vd20) v(g21) i(vd21) v(g22) i(vd22) v(g23) i(vd23)
+ v(g24) i(vd24)
wrdata sim/out/t1f/t1f_w01_state.csv v(x20.xfe.x1) v(x20.xfe.x2) v(x20.xfe.x3) v(x20.xfe.x4) v(x20.xfe.x5) v(x20.xfe.x6) v(x20.xfe.x7) v(x20.xfe.x8)
+ v(x20.xfe.x9) v(x20.xfe.x10) v(x20.xfe.x11) v(x20.xfe.x12) v(x20.xfe.x13) v(x20.xfe.x14) v(x20.xfe.x15) v(x20.xfe.x16)
+ v(x20.m) v(g20)
.endc
.end
