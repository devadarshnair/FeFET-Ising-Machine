* t3a_disturb.cir -- generated by circuit/tcam/make_tcam.py write
* Test 3a disturb: single set-C FeFETs (low or high V_th) at the inhibit voltage +-2 V for 255 x 10 us
* (one continuous 2.55 ms stress = 255 other rows written once), then 2 s at 0 V. l0/h0: no stress.
* lp3 ... hm3: the same at +-V_W/3 = +-1.33 V (information only).
.include ../../device/ngspice/fefet_preisach.lib
.include ../../models/mosfet/standin45_bsim4.lib
.include tcam_cells.lib
.options reltol=1e-3 abstol=1e-15 method=gear
Vg_lp g_lp 0 pwl(
+ 0 0 1e-06 0 1.005e-06 2 0.002551005 2 0.00255101 0)
Xlp g_lp 0 0 0 fefet_c16 x0_1=1 x0_2=1 x0_3=1 x0_4=1 x0_5=1 x0_6=1
+ x0_7=1 x0_8=1 x0_9=1 x0_10=1 x0_11=1 x0_12=1
+ x0_13=1 x0_14=0.999999988 x0_15=1.00000021 x0_16=0.999959662
.ic v(xlp.m)=0.424804359
Vg_lm g_lm 0 pwl(
+ 0 0 1e-06 0 1.005e-06 -2 0.002551005 -2 0.00255101 0)
Xlm g_lm 0 0 0 fefet_c16 x0_1=1 x0_2=1 x0_3=1 x0_4=1 x0_5=1 x0_6=1
+ x0_7=1 x0_8=1 x0_9=1 x0_10=1 x0_11=1 x0_12=1
+ x0_13=1 x0_14=0.999999988 x0_15=1.00000021 x0_16=0.999959662
.ic v(xlm.m)=0.424804359
Vg_hp g_hp 0 pwl(
+ 0 0 1e-06 0 1.005e-06 2 0.002551005 2 0.00255101 0)
Xhp g_hp 0 0 0 fefet_c16 x0_1=-1 x0_2=-1 x0_3=-1 x0_4=-1 x0_5=-1 x0_6=-1
+ x0_7=-1 x0_8=-1 x0_9=-1 x0_10=-1 x0_11=-1 x0_12=-1
+ x0_13=-1 x0_14=-1 x0_15=-1 x0_16=-1
.ic v(xhp.m)=-0.277154442
Vg_hm g_hm 0 pwl(
+ 0 0 1e-06 0 1.005e-06 -2 0.002551005 -2 0.00255101 0)
Xhm g_hm 0 0 0 fefet_c16 x0_1=-1 x0_2=-1 x0_3=-1 x0_4=-1 x0_5=-1 x0_6=-1
+ x0_7=-1 x0_8=-1 x0_9=-1 x0_10=-1 x0_11=-1 x0_12=-1
+ x0_13=-1 x0_14=-1 x0_15=-1 x0_16=-1
.ic v(xhm.m)=-0.277154442
Vg_l0 g_l0 0 pwl(
+ 0 0)
Xl0 g_l0 0 0 0 fefet_c16 x0_1=1 x0_2=1 x0_3=1 x0_4=1 x0_5=1 x0_6=1
+ x0_7=1 x0_8=1 x0_9=1 x0_10=1 x0_11=1 x0_12=1
+ x0_13=1 x0_14=0.999999988 x0_15=1.00000021 x0_16=0.999959662
.ic v(xl0.m)=0.424804359
Vg_h0 g_h0 0 pwl(
+ 0 0)
Xh0 g_h0 0 0 0 fefet_c16 x0_1=-1 x0_2=-1 x0_3=-1 x0_4=-1 x0_5=-1 x0_6=-1
+ x0_7=-1 x0_8=-1 x0_9=-1 x0_10=-1 x0_11=-1 x0_12=-1
+ x0_13=-1 x0_14=-1 x0_15=-1 x0_16=-1
.ic v(xh0.m)=-0.277154442
Vg_lp3 g_lp3 0 pwl(
+ 0 0 1e-06 0 1.005e-06 1.33333 0.002551005 1.33333 0.00255101 0)
Xlp3 g_lp3 0 0 0 fefet_c16 x0_1=1 x0_2=1 x0_3=1 x0_4=1 x0_5=1 x0_6=1
+ x0_7=1 x0_8=1 x0_9=1 x0_10=1 x0_11=1 x0_12=1
+ x0_13=1 x0_14=0.999999988 x0_15=1.00000021 x0_16=0.999959662
.ic v(xlp3.m)=0.424804359
Vg_lm3 g_lm3 0 pwl(
+ 0 0 1e-06 0 1.005e-06 -1.33333 0.002551005 -1.33333 0.00255101 0)
Xlm3 g_lm3 0 0 0 fefet_c16 x0_1=1 x0_2=1 x0_3=1 x0_4=1 x0_5=1 x0_6=1
+ x0_7=1 x0_8=1 x0_9=1 x0_10=1 x0_11=1 x0_12=1
+ x0_13=1 x0_14=0.999999988 x0_15=1.00000021 x0_16=0.999959662
.ic v(xlm3.m)=0.424804359
Vg_hp3 g_hp3 0 pwl(
+ 0 0 1e-06 0 1.005e-06 1.33333 0.002551005 1.33333 0.00255101 0)
Xhp3 g_hp3 0 0 0 fefet_c16 x0_1=-1 x0_2=-1 x0_3=-1 x0_4=-1 x0_5=-1 x0_6=-1
+ x0_7=-1 x0_8=-1 x0_9=-1 x0_10=-1 x0_11=-1 x0_12=-1
+ x0_13=-1 x0_14=-1 x0_15=-1 x0_16=-1
.ic v(xhp3.m)=-0.277154442
Vg_hm3 g_hm3 0 pwl(
+ 0 0 1e-06 0 1.005e-06 -1.33333 0.002551005 -1.33333 0.00255101 0)
Xhm3 g_hm3 0 0 0 fefet_c16 x0_1=-1 x0_2=-1 x0_3=-1 x0_4=-1 x0_5=-1 x0_6=-1
+ x0_7=-1 x0_8=-1 x0_9=-1 x0_10=-1 x0_11=-1 x0_12=-1
+ x0_13=-1 x0_14=-1 x0_15=-1 x0_16=-1
.ic v(xhm3.m)=-0.277154442
.control
set wr_singlescale
set wr_vecnames
tran 1n 2.00255101 0 0.0100128 uic
wrdata sim/out/t3a/t3a_disturb.csv v(xlp.xfe.x1) v(xlp.xfe.x2) v(xlp.xfe.x3) v(xlp.xfe.x4) v(xlp.xfe.x5) v(xlp.xfe.x6) v(xlp.xfe.x7) v(xlp.xfe.x8)
+ v(xlp.xfe.x9) v(xlp.xfe.x10) v(xlp.xfe.x11) v(xlp.xfe.x12) v(xlp.xfe.x13) v(xlp.xfe.x14) v(xlp.xfe.x15) v(xlp.xfe.x16)
+ v(xlp.m) v(xlm.xfe.x1) v(xlm.xfe.x2) v(xlm.xfe.x3) v(xlm.xfe.x4) v(xlm.xfe.x5) v(xlm.xfe.x6) v(xlm.xfe.x7)
+ v(xlm.xfe.x8) v(xlm.xfe.x9) v(xlm.xfe.x10) v(xlm.xfe.x11) v(xlm.xfe.x12) v(xlm.xfe.x13) v(xlm.xfe.x14) v(xlm.xfe.x15)
+ v(xlm.xfe.x16) v(xlm.m) v(xhp.xfe.x1) v(xhp.xfe.x2) v(xhp.xfe.x3) v(xhp.xfe.x4) v(xhp.xfe.x5) v(xhp.xfe.x6)
+ v(xhp.xfe.x7) v(xhp.xfe.x8) v(xhp.xfe.x9) v(xhp.xfe.x10) v(xhp.xfe.x11) v(xhp.xfe.x12) v(xhp.xfe.x13) v(xhp.xfe.x14)
+ v(xhp.xfe.x15) v(xhp.xfe.x16) v(xhp.m) v(xhm.xfe.x1) v(xhm.xfe.x2) v(xhm.xfe.x3) v(xhm.xfe.x4) v(xhm.xfe.x5)
+ v(xhm.xfe.x6) v(xhm.xfe.x7) v(xhm.xfe.x8) v(xhm.xfe.x9) v(xhm.xfe.x10) v(xhm.xfe.x11) v(xhm.xfe.x12) v(xhm.xfe.x13)
+ v(xhm.xfe.x14) v(xhm.xfe.x15) v(xhm.xfe.x16) v(xhm.m) v(xl0.xfe.x1) v(xl0.xfe.x2) v(xl0.xfe.x3) v(xl0.xfe.x4)
+ v(xl0.xfe.x5) v(xl0.xfe.x6) v(xl0.xfe.x7) v(xl0.xfe.x8) v(xl0.xfe.x9) v(xl0.xfe.x10) v(xl0.xfe.x11) v(xl0.xfe.x12)
+ v(xl0.xfe.x13) v(xl0.xfe.x14) v(xl0.xfe.x15) v(xl0.xfe.x16) v(xl0.m) v(xh0.xfe.x1) v(xh0.xfe.x2) v(xh0.xfe.x3)
+ v(xh0.xfe.x4) v(xh0.xfe.x5) v(xh0.xfe.x6) v(xh0.xfe.x7) v(xh0.xfe.x8) v(xh0.xfe.x9) v(xh0.xfe.x10) v(xh0.xfe.x11)
+ v(xh0.xfe.x12) v(xh0.xfe.x13) v(xh0.xfe.x14) v(xh0.xfe.x15) v(xh0.xfe.x16) v(xh0.m) v(xlp3.xfe.x1) v(xlp3.xfe.x2)
+ v(xlp3.xfe.x3) v(xlp3.xfe.x4) v(xlp3.xfe.x5) v(xlp3.xfe.x6) v(xlp3.xfe.x7) v(xlp3.xfe.x8) v(xlp3.xfe.x9) v(xlp3.xfe.x10)
+ v(xlp3.xfe.x11) v(xlp3.xfe.x12) v(xlp3.xfe.x13) v(xlp3.xfe.x14) v(xlp3.xfe.x15) v(xlp3.xfe.x16) v(xlp3.m) v(xlm3.xfe.x1)
+ v(xlm3.xfe.x2) v(xlm3.xfe.x3) v(xlm3.xfe.x4) v(xlm3.xfe.x5) v(xlm3.xfe.x6) v(xlm3.xfe.x7) v(xlm3.xfe.x8) v(xlm3.xfe.x9)
+ v(xlm3.xfe.x10) v(xlm3.xfe.x11) v(xlm3.xfe.x12) v(xlm3.xfe.x13) v(xlm3.xfe.x14) v(xlm3.xfe.x15) v(xlm3.xfe.x16) v(xlm3.m)
+ v(xhp3.xfe.x1) v(xhp3.xfe.x2) v(xhp3.xfe.x3) v(xhp3.xfe.x4) v(xhp3.xfe.x5) v(xhp3.xfe.x6) v(xhp3.xfe.x7) v(xhp3.xfe.x8)
+ v(xhp3.xfe.x9) v(xhp3.xfe.x10) v(xhp3.xfe.x11) v(xhp3.xfe.x12) v(xhp3.xfe.x13) v(xhp3.xfe.x14) v(xhp3.xfe.x15) v(xhp3.xfe.x16)
+ v(xhp3.m) v(xhm3.xfe.x1) v(xhm3.xfe.x2) v(xhm3.xfe.x3) v(xhm3.xfe.x4) v(xhm3.xfe.x5) v(xhm3.xfe.x6) v(xhm3.xfe.x7)
+ v(xhm3.xfe.x8) v(xhm3.xfe.x9) v(xhm3.xfe.x10) v(xhm3.xfe.x11) v(xhm3.xfe.x12) v(xhm3.xfe.x13) v(xhm3.xfe.x14) v(xhm3.xfe.x15)
+ v(xhm3.xfe.x16) v(xhm3.m)
.endc
.end
