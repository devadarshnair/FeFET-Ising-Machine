* t3c_word64_m64.cir -- generated by circuit/tcam/make_tcam.py search
* Test 3c: one 64-cell word (pattern 10110100 x 8) searched with 64 mismatches.
* FeFETs with frozen domain states (fefet_c16_frozen), checked against the full model in 3b.
* Evaluate window 8.0 ns; two cycles, the second is measured.
.include ../../device/ngspice/fefet_preisach.lib
.include ../../models/mosfet/standin45_bsim4.lib
.include tcam_cells.lib
.options reltol=1e-3 abstol=1e-15 method=gear
Vpreb preb 0 pwl(
+ 0 0 1e-09 0 1.02e-09 1 9.38e-09 1 9.4e-09 0 1.02e-08 0
+ 1.022e-08 1 1.858e-08 1 1.86e-08 0)
Vact in_act 0 pwl(
+ 0 1.1 1.2e-09 1.1 1.22e-09 0 9.2e-09 0 9.22e-09 1.1 1.04e-08 1.1
+ 1.042e-08 0 1.84e-08 0 1.842e-08 1.1)
* word 0: stored 1011010010110100101101001011010010110100101101001011010010110100 key 0100101101001011010010110100101101001011010010110100101101001011 -> 64 mismatch(es)
Vdd0 vdd0 0 1.0
Vs0 vs0 0 1.1
Xd0_0a vs0 sl0_0 vs0 sldrv
Xd0_0b in_act slb0_0 vs0 sldrv
Cs0_0a sl0_0 0 1e-16
Cs0_0b slb0_0 0 1e-16
Xc0_0 sl0_0 slb0_0 ml0_0 0 0 tcam2f_frozen dvgl=0 dvgr=0
.ic v(xc0_0.xl.m)=-0.277154442 v(xc0_0.xr.m)=0.424804359
Cm0_0 ml0_0 0 1e-16
Rm0_0 ml0_0 ml0_1 3.2
Xd0_1a in_act sl0_1 vs0 sldrv
Xd0_1b vs0 slb0_1 vs0 sldrv
Cs0_1a sl0_1 0 1e-16
Cs0_1b slb0_1 0 1e-16
Xc0_1 sl0_1 slb0_1 ml0_1 0 0 tcam2f_frozen dvgl=0 dvgr=0
.ic v(xc0_1.xl.m)=0.424804359 v(xc0_1.xr.m)=-0.277154442
Cm0_1 ml0_1 0 1e-16
Rm0_1 ml0_1 ml0_2 3.2
Xd0_2a vs0 sl0_2 vs0 sldrv
Xd0_2b in_act slb0_2 vs0 sldrv
Cs0_2a sl0_2 0 1e-16
Cs0_2b slb0_2 0 1e-16
Xc0_2 sl0_2 slb0_2 ml0_2 0 0 tcam2f_frozen dvgl=0 dvgr=0
.ic v(xc0_2.xl.m)=-0.277154442 v(xc0_2.xr.m)=0.424804359
Cm0_2 ml0_2 0 1e-16
Rm0_2 ml0_2 ml0_3 3.2
Xd0_3a vs0 sl0_3 vs0 sldrv
Xd0_3b in_act slb0_3 vs0 sldrv
Cs0_3a sl0_3 0 1e-16
Cs0_3b slb0_3 0 1e-16
Xc0_3 sl0_3 slb0_3 ml0_3 0 0 tcam2f_frozen dvgl=0 dvgr=0
.ic v(xc0_3.xl.m)=-0.277154442 v(xc0_3.xr.m)=0.424804359
Cm0_3 ml0_3 0 1e-16
Rm0_3 ml0_3 ml0_4 3.2
Xd0_4a in_act sl0_4 vs0 sldrv
Xd0_4b vs0 slb0_4 vs0 sldrv
Cs0_4a sl0_4 0 1e-16
Cs0_4b slb0_4 0 1e-16
Xc0_4 sl0_4 slb0_4 ml0_4 0 0 tcam2f_frozen dvgl=0 dvgr=0
.ic v(xc0_4.xl.m)=0.424804359 v(xc0_4.xr.m)=-0.277154442
Cm0_4 ml0_4 0 1e-16
Rm0_4 ml0_4 ml0_5 3.2
Xd0_5a vs0 sl0_5 vs0 sldrv
Xd0_5b in_act slb0_5 vs0 sldrv
Cs0_5a sl0_5 0 1e-16
Cs0_5b slb0_5 0 1e-16
Xc0_5 sl0_5 slb0_5 ml0_5 0 0 tcam2f_frozen dvgl=0 dvgr=0
.ic v(xc0_5.xl.m)=-0.277154442 v(xc0_5.xr.m)=0.424804359
Cm0_5 ml0_5 0 1e-16
Rm0_5 ml0_5 ml0_6 3.2
Xd0_6a in_act sl0_6 vs0 sldrv
Xd0_6b vs0 slb0_6 vs0 sldrv
Cs0_6a sl0_6 0 1e-16
Cs0_6b slb0_6 0 1e-16
Xc0_6 sl0_6 slb0_6 ml0_6 0 0 tcam2f_frozen dvgl=0 dvgr=0
.ic v(xc0_6.xl.m)=0.424804359 v(xc0_6.xr.m)=-0.277154442
Cm0_6 ml0_6 0 1e-16
Rm0_6 ml0_6 ml0_7 3.2
Xd0_7a in_act sl0_7 vs0 sldrv
Xd0_7b vs0 slb0_7 vs0 sldrv
Cs0_7a sl0_7 0 1e-16
Cs0_7b slb0_7 0 1e-16
Xc0_7 sl0_7 slb0_7 ml0_7 0 0 tcam2f_frozen dvgl=0 dvgr=0
.ic v(xc0_7.xl.m)=0.424804359 v(xc0_7.xr.m)=-0.277154442
Cm0_7 ml0_7 0 1e-16
Rm0_7 ml0_7 ml0_8 3.2
Xd0_8a vs0 sl0_8 vs0 sldrv
Xd0_8b in_act slb0_8 vs0 sldrv
Cs0_8a sl0_8 0 1e-16
Cs0_8b slb0_8 0 1e-16
Xc0_8 sl0_8 slb0_8 ml0_8 0 0 tcam2f_frozen dvgl=0 dvgr=0
.ic v(xc0_8.xl.m)=-0.277154442 v(xc0_8.xr.m)=0.424804359
Cm0_8 ml0_8 0 1e-16
Rm0_8 ml0_8 ml0_9 3.2
Xd0_9a in_act sl0_9 vs0 sldrv
Xd0_9b vs0 slb0_9 vs0 sldrv
Cs0_9a sl0_9 0 1e-16
Cs0_9b slb0_9 0 1e-16
Xc0_9 sl0_9 slb0_9 ml0_9 0 0 tcam2f_frozen dvgl=0 dvgr=0
.ic v(xc0_9.xl.m)=0.424804359 v(xc0_9.xr.m)=-0.277154442
Cm0_9 ml0_9 0 1e-16
Rm0_9 ml0_9 ml0_10 3.2
Xd0_10a vs0 sl0_10 vs0 sldrv
Xd0_10b in_act slb0_10 vs0 sldrv
Cs0_10a sl0_10 0 1e-16
Cs0_10b slb0_10 0 1e-16
Xc0_10 sl0_10 slb0_10 ml0_10 0 0 tcam2f_frozen dvgl=0 dvgr=0
.ic v(xc0_10.xl.m)=-0.277154442 v(xc0_10.xr.m)=0.424804359
Cm0_10 ml0_10 0 1e-16
Rm0_10 ml0_10 ml0_11 3.2
Xd0_11a vs0 sl0_11 vs0 sldrv
Xd0_11b in_act slb0_11 vs0 sldrv
Cs0_11a sl0_11 0 1e-16
Cs0_11b slb0_11 0 1e-16
Xc0_11 sl0_11 slb0_11 ml0_11 0 0 tcam2f_frozen dvgl=0 dvgr=0
.ic v(xc0_11.xl.m)=-0.277154442 v(xc0_11.xr.m)=0.424804359
Cm0_11 ml0_11 0 1e-16
Rm0_11 ml0_11 ml0_12 3.2
Xd0_12a in_act sl0_12 vs0 sldrv
Xd0_12b vs0 slb0_12 vs0 sldrv
Cs0_12a sl0_12 0 1e-16
Cs0_12b slb0_12 0 1e-16
Xc0_12 sl0_12 slb0_12 ml0_12 0 0 tcam2f_frozen dvgl=0 dvgr=0
.ic v(xc0_12.xl.m)=0.424804359 v(xc0_12.xr.m)=-0.277154442
Cm0_12 ml0_12 0 1e-16
Rm0_12 ml0_12 ml0_13 3.2
Xd0_13a vs0 sl0_13 vs0 sldrv
Xd0_13b in_act slb0_13 vs0 sldrv
Cs0_13a sl0_13 0 1e-16
Cs0_13b slb0_13 0 1e-16
Xc0_13 sl0_13 slb0_13 ml0_13 0 0 tcam2f_frozen dvgl=0 dvgr=0
.ic v(xc0_13.xl.m)=-0.277154442 v(xc0_13.xr.m)=0.424804359
Cm0_13 ml0_13 0 1e-16
Rm0_13 ml0_13 ml0_14 3.2
Xd0_14a in_act sl0_14 vs0 sldrv
Xd0_14b vs0 slb0_14 vs0 sldrv
Cs0_14a sl0_14 0 1e-16
Cs0_14b slb0_14 0 1e-16
Xc0_14 sl0_14 slb0_14 ml0_14 0 0 tcam2f_frozen dvgl=0 dvgr=0
.ic v(xc0_14.xl.m)=0.424804359 v(xc0_14.xr.m)=-0.277154442
Cm0_14 ml0_14 0 1e-16
Rm0_14 ml0_14 ml0_15 3.2
Xd0_15a in_act sl0_15 vs0 sldrv
Xd0_15b vs0 slb0_15 vs0 sldrv
Cs0_15a sl0_15 0 1e-16
Cs0_15b slb0_15 0 1e-16
Xc0_15 sl0_15 slb0_15 ml0_15 0 0 tcam2f_frozen dvgl=0 dvgr=0
.ic v(xc0_15.xl.m)=0.424804359 v(xc0_15.xr.m)=-0.277154442
Cm0_15 ml0_15 0 1e-16
Rm0_15 ml0_15 ml0_16 3.2
Xd0_16a vs0 sl0_16 vs0 sldrv
Xd0_16b in_act slb0_16 vs0 sldrv
Cs0_16a sl0_16 0 1e-16
Cs0_16b slb0_16 0 1e-16
Xc0_16 sl0_16 slb0_16 ml0_16 0 0 tcam2f_frozen dvgl=0 dvgr=0
.ic v(xc0_16.xl.m)=-0.277154442 v(xc0_16.xr.m)=0.424804359
Cm0_16 ml0_16 0 1e-16
Rm0_16 ml0_16 ml0_17 3.2
Xd0_17a in_act sl0_17 vs0 sldrv
Xd0_17b vs0 slb0_17 vs0 sldrv
Cs0_17a sl0_17 0 1e-16
Cs0_17b slb0_17 0 1e-16
Xc0_17 sl0_17 slb0_17 ml0_17 0 0 tcam2f_frozen dvgl=0 dvgr=0
.ic v(xc0_17.xl.m)=0.424804359 v(xc0_17.xr.m)=-0.277154442
Cm0_17 ml0_17 0 1e-16
Rm0_17 ml0_17 ml0_18 3.2
Xd0_18a vs0 sl0_18 vs0 sldrv
Xd0_18b in_act slb0_18 vs0 sldrv
Cs0_18a sl0_18 0 1e-16
Cs0_18b slb0_18 0 1e-16
Xc0_18 sl0_18 slb0_18 ml0_18 0 0 tcam2f_frozen dvgl=0 dvgr=0
.ic v(xc0_18.xl.m)=-0.277154442 v(xc0_18.xr.m)=0.424804359
Cm0_18 ml0_18 0 1e-16
Rm0_18 ml0_18 ml0_19 3.2
Xd0_19a vs0 sl0_19 vs0 sldrv
Xd0_19b in_act slb0_19 vs0 sldrv
Cs0_19a sl0_19 0 1e-16
Cs0_19b slb0_19 0 1e-16
Xc0_19 sl0_19 slb0_19 ml0_19 0 0 tcam2f_frozen dvgl=0 dvgr=0
.ic v(xc0_19.xl.m)=-0.277154442 v(xc0_19.xr.m)=0.424804359
Cm0_19 ml0_19 0 1e-16
Rm0_19 ml0_19 ml0_20 3.2
Xd0_20a in_act sl0_20 vs0 sldrv
Xd0_20b vs0 slb0_20 vs0 sldrv
Cs0_20a sl0_20 0 1e-16
Cs0_20b slb0_20 0 1e-16
Xc0_20 sl0_20 slb0_20 ml0_20 0 0 tcam2f_frozen dvgl=0 dvgr=0
.ic v(xc0_20.xl.m)=0.424804359 v(xc0_20.xr.m)=-0.277154442
Cm0_20 ml0_20 0 1e-16
Rm0_20 ml0_20 ml0_21 3.2
Xd0_21a vs0 sl0_21 vs0 sldrv
Xd0_21b in_act slb0_21 vs0 sldrv
Cs0_21a sl0_21 0 1e-16
Cs0_21b slb0_21 0 1e-16
Xc0_21 sl0_21 slb0_21 ml0_21 0 0 tcam2f_frozen dvgl=0 dvgr=0
.ic v(xc0_21.xl.m)=-0.277154442 v(xc0_21.xr.m)=0.424804359
Cm0_21 ml0_21 0 1e-16
Rm0_21 ml0_21 ml0_22 3.2
Xd0_22a in_act sl0_22 vs0 sldrv
Xd0_22b vs0 slb0_22 vs0 sldrv
Cs0_22a sl0_22 0 1e-16
Cs0_22b slb0_22 0 1e-16
Xc0_22 sl0_22 slb0_22 ml0_22 0 0 tcam2f_frozen dvgl=0 dvgr=0
.ic v(xc0_22.xl.m)=0.424804359 v(xc0_22.xr.m)=-0.277154442
Cm0_22 ml0_22 0 1e-16
Rm0_22 ml0_22 ml0_23 3.2
Xd0_23a in_act sl0_23 vs0 sldrv
Xd0_23b vs0 slb0_23 vs0 sldrv
Cs0_23a sl0_23 0 1e-16
Cs0_23b slb0_23 0 1e-16
Xc0_23 sl0_23 slb0_23 ml0_23 0 0 tcam2f_frozen dvgl=0 dvgr=0
.ic v(xc0_23.xl.m)=0.424804359 v(xc0_23.xr.m)=-0.277154442
Cm0_23 ml0_23 0 1e-16
Rm0_23 ml0_23 ml0_24 3.2
Xd0_24a vs0 sl0_24 vs0 sldrv
Xd0_24b in_act slb0_24 vs0 sldrv
Cs0_24a sl0_24 0 1e-16
Cs0_24b slb0_24 0 1e-16
Xc0_24 sl0_24 slb0_24 ml0_24 0 0 tcam2f_frozen dvgl=0 dvgr=0
.ic v(xc0_24.xl.m)=-0.277154442 v(xc0_24.xr.m)=0.424804359
Cm0_24 ml0_24 0 1e-16
Rm0_24 ml0_24 ml0_25 3.2
Xd0_25a in_act sl0_25 vs0 sldrv
Xd0_25b vs0 slb0_25 vs0 sldrv
Cs0_25a sl0_25 0 1e-16
Cs0_25b slb0_25 0 1e-16
Xc0_25 sl0_25 slb0_25 ml0_25 0 0 tcam2f_frozen dvgl=0 dvgr=0
.ic v(xc0_25.xl.m)=0.424804359 v(xc0_25.xr.m)=-0.277154442
Cm0_25 ml0_25 0 1e-16
Rm0_25 ml0_25 ml0_26 3.2
Xd0_26a vs0 sl0_26 vs0 sldrv
Xd0_26b in_act slb0_26 vs0 sldrv
Cs0_26a sl0_26 0 1e-16
Cs0_26b slb0_26 0 1e-16
Xc0_26 sl0_26 slb0_26 ml0_26 0 0 tcam2f_frozen dvgl=0 dvgr=0
.ic v(xc0_26.xl.m)=-0.277154442 v(xc0_26.xr.m)=0.424804359
Cm0_26 ml0_26 0 1e-16
Rm0_26 ml0_26 ml0_27 3.2
Xd0_27a vs0 sl0_27 vs0 sldrv
Xd0_27b in_act slb0_27 vs0 sldrv
Cs0_27a sl0_27 0 1e-16
Cs0_27b slb0_27 0 1e-16
Xc0_27 sl0_27 slb0_27 ml0_27 0 0 tcam2f_frozen dvgl=0 dvgr=0
.ic v(xc0_27.xl.m)=-0.277154442 v(xc0_27.xr.m)=0.424804359
Cm0_27 ml0_27 0 1e-16
Rm0_27 ml0_27 ml0_28 3.2
Xd0_28a in_act sl0_28 vs0 sldrv
Xd0_28b vs0 slb0_28 vs0 sldrv
Cs0_28a sl0_28 0 1e-16
Cs0_28b slb0_28 0 1e-16
Xc0_28 sl0_28 slb0_28 ml0_28 0 0 tcam2f_frozen dvgl=0 dvgr=0
.ic v(xc0_28.xl.m)=0.424804359 v(xc0_28.xr.m)=-0.277154442
Cm0_28 ml0_28 0 1e-16
Rm0_28 ml0_28 ml0_29 3.2
Xd0_29a vs0 sl0_29 vs0 sldrv
Xd0_29b in_act slb0_29 vs0 sldrv
Cs0_29a sl0_29 0 1e-16
Cs0_29b slb0_29 0 1e-16
Xc0_29 sl0_29 slb0_29 ml0_29 0 0 tcam2f_frozen dvgl=0 dvgr=0
.ic v(xc0_29.xl.m)=-0.277154442 v(xc0_29.xr.m)=0.424804359
Cm0_29 ml0_29 0 1e-16
Rm0_29 ml0_29 ml0_30 3.2
Xd0_30a in_act sl0_30 vs0 sldrv
Xd0_30b vs0 slb0_30 vs0 sldrv
Cs0_30a sl0_30 0 1e-16
Cs0_30b slb0_30 0 1e-16
Xc0_30 sl0_30 slb0_30 ml0_30 0 0 tcam2f_frozen dvgl=0 dvgr=0
.ic v(xc0_30.xl.m)=0.424804359 v(xc0_30.xr.m)=-0.277154442
Cm0_30 ml0_30 0 1e-16
Rm0_30 ml0_30 ml0_31 3.2
Xd0_31a in_act sl0_31 vs0 sldrv
Xd0_31b vs0 slb0_31 vs0 sldrv
Cs0_31a sl0_31 0 1e-16
Cs0_31b slb0_31 0 1e-16
Xc0_31 sl0_31 slb0_31 ml0_31 0 0 tcam2f_frozen dvgl=0 dvgr=0
.ic v(xc0_31.xl.m)=0.424804359 v(xc0_31.xr.m)=-0.277154442
Cm0_31 ml0_31 0 1e-16
Rm0_31 ml0_31 ml0_32 3.2
Xd0_32a vs0 sl0_32 vs0 sldrv
Xd0_32b in_act slb0_32 vs0 sldrv
Cs0_32a sl0_32 0 1e-16
Cs0_32b slb0_32 0 1e-16
Xc0_32 sl0_32 slb0_32 ml0_32 0 0 tcam2f_frozen dvgl=0 dvgr=0
.ic v(xc0_32.xl.m)=-0.277154442 v(xc0_32.xr.m)=0.424804359
Cm0_32 ml0_32 0 1e-16
Rm0_32 ml0_32 ml0_33 3.2
Xd0_33a in_act sl0_33 vs0 sldrv
Xd0_33b vs0 slb0_33 vs0 sldrv
Cs0_33a sl0_33 0 1e-16
Cs0_33b slb0_33 0 1e-16
Xc0_33 sl0_33 slb0_33 ml0_33 0 0 tcam2f_frozen dvgl=0 dvgr=0
.ic v(xc0_33.xl.m)=0.424804359 v(xc0_33.xr.m)=-0.277154442
Cm0_33 ml0_33 0 1e-16
Rm0_33 ml0_33 ml0_34 3.2
Xd0_34a vs0 sl0_34 vs0 sldrv
Xd0_34b in_act slb0_34 vs0 sldrv
Cs0_34a sl0_34 0 1e-16
Cs0_34b slb0_34 0 1e-16
Xc0_34 sl0_34 slb0_34 ml0_34 0 0 tcam2f_frozen dvgl=0 dvgr=0
.ic v(xc0_34.xl.m)=-0.277154442 v(xc0_34.xr.m)=0.424804359
Cm0_34 ml0_34 0 1e-16
Rm0_34 ml0_34 ml0_35 3.2
Xd0_35a vs0 sl0_35 vs0 sldrv
Xd0_35b in_act slb0_35 vs0 sldrv
Cs0_35a sl0_35 0 1e-16
Cs0_35b slb0_35 0 1e-16
Xc0_35 sl0_35 slb0_35 ml0_35 0 0 tcam2f_frozen dvgl=0 dvgr=0
.ic v(xc0_35.xl.m)=-0.277154442 v(xc0_35.xr.m)=0.424804359
Cm0_35 ml0_35 0 1e-16
Rm0_35 ml0_35 ml0_36 3.2
Xd0_36a in_act sl0_36 vs0 sldrv
Xd0_36b vs0 slb0_36 vs0 sldrv
Cs0_36a sl0_36 0 1e-16
Cs0_36b slb0_36 0 1e-16
Xc0_36 sl0_36 slb0_36 ml0_36 0 0 tcam2f_frozen dvgl=0 dvgr=0
.ic v(xc0_36.xl.m)=0.424804359 v(xc0_36.xr.m)=-0.277154442
Cm0_36 ml0_36 0 1e-16
Rm0_36 ml0_36 ml0_37 3.2
Xd0_37a vs0 sl0_37 vs0 sldrv
Xd0_37b in_act slb0_37 vs0 sldrv
Cs0_37a sl0_37 0 1e-16
Cs0_37b slb0_37 0 1e-16
Xc0_37 sl0_37 slb0_37 ml0_37 0 0 tcam2f_frozen dvgl=0 dvgr=0
.ic v(xc0_37.xl.m)=-0.277154442 v(xc0_37.xr.m)=0.424804359
Cm0_37 ml0_37 0 1e-16
Rm0_37 ml0_37 ml0_38 3.2
Xd0_38a in_act sl0_38 vs0 sldrv
Xd0_38b vs0 slb0_38 vs0 sldrv
Cs0_38a sl0_38 0 1e-16
Cs0_38b slb0_38 0 1e-16
Xc0_38 sl0_38 slb0_38 ml0_38 0 0 tcam2f_frozen dvgl=0 dvgr=0
.ic v(xc0_38.xl.m)=0.424804359 v(xc0_38.xr.m)=-0.277154442
Cm0_38 ml0_38 0 1e-16
Rm0_38 ml0_38 ml0_39 3.2
Xd0_39a in_act sl0_39 vs0 sldrv
Xd0_39b vs0 slb0_39 vs0 sldrv
Cs0_39a sl0_39 0 1e-16
Cs0_39b slb0_39 0 1e-16
Xc0_39 sl0_39 slb0_39 ml0_39 0 0 tcam2f_frozen dvgl=0 dvgr=0
.ic v(xc0_39.xl.m)=0.424804359 v(xc0_39.xr.m)=-0.277154442
Cm0_39 ml0_39 0 1e-16
Rm0_39 ml0_39 ml0_40 3.2
Xd0_40a vs0 sl0_40 vs0 sldrv
Xd0_40b in_act slb0_40 vs0 sldrv
Cs0_40a sl0_40 0 1e-16
Cs0_40b slb0_40 0 1e-16
Xc0_40 sl0_40 slb0_40 ml0_40 0 0 tcam2f_frozen dvgl=0 dvgr=0
.ic v(xc0_40.xl.m)=-0.277154442 v(xc0_40.xr.m)=0.424804359
Cm0_40 ml0_40 0 1e-16
Rm0_40 ml0_40 ml0_41 3.2
Xd0_41a in_act sl0_41 vs0 sldrv
Xd0_41b vs0 slb0_41 vs0 sldrv
Cs0_41a sl0_41 0 1e-16
Cs0_41b slb0_41 0 1e-16
Xc0_41 sl0_41 slb0_41 ml0_41 0 0 tcam2f_frozen dvgl=0 dvgr=0
.ic v(xc0_41.xl.m)=0.424804359 v(xc0_41.xr.m)=-0.277154442
Cm0_41 ml0_41 0 1e-16
Rm0_41 ml0_41 ml0_42 3.2
Xd0_42a vs0 sl0_42 vs0 sldrv
Xd0_42b in_act slb0_42 vs0 sldrv
Cs0_42a sl0_42 0 1e-16
Cs0_42b slb0_42 0 1e-16
Xc0_42 sl0_42 slb0_42 ml0_42 0 0 tcam2f_frozen dvgl=0 dvgr=0
.ic v(xc0_42.xl.m)=-0.277154442 v(xc0_42.xr.m)=0.424804359
Cm0_42 ml0_42 0 1e-16
Rm0_42 ml0_42 ml0_43 3.2
Xd0_43a vs0 sl0_43 vs0 sldrv
Xd0_43b in_act slb0_43 vs0 sldrv
Cs0_43a sl0_43 0 1e-16
Cs0_43b slb0_43 0 1e-16
Xc0_43 sl0_43 slb0_43 ml0_43 0 0 tcam2f_frozen dvgl=0 dvgr=0
.ic v(xc0_43.xl.m)=-0.277154442 v(xc0_43.xr.m)=0.424804359
Cm0_43 ml0_43 0 1e-16
Rm0_43 ml0_43 ml0_44 3.2
Xd0_44a in_act sl0_44 vs0 sldrv
Xd0_44b vs0 slb0_44 vs0 sldrv
Cs0_44a sl0_44 0 1e-16
Cs0_44b slb0_44 0 1e-16
Xc0_44 sl0_44 slb0_44 ml0_44 0 0 tcam2f_frozen dvgl=0 dvgr=0
.ic v(xc0_44.xl.m)=0.424804359 v(xc0_44.xr.m)=-0.277154442
Cm0_44 ml0_44 0 1e-16
Rm0_44 ml0_44 ml0_45 3.2
Xd0_45a vs0 sl0_45 vs0 sldrv
Xd0_45b in_act slb0_45 vs0 sldrv
Cs0_45a sl0_45 0 1e-16
Cs0_45b slb0_45 0 1e-16
Xc0_45 sl0_45 slb0_45 ml0_45 0 0 tcam2f_frozen dvgl=0 dvgr=0
.ic v(xc0_45.xl.m)=-0.277154442 v(xc0_45.xr.m)=0.424804359
Cm0_45 ml0_45 0 1e-16
Rm0_45 ml0_45 ml0_46 3.2
Xd0_46a in_act sl0_46 vs0 sldrv
Xd0_46b vs0 slb0_46 vs0 sldrv
Cs0_46a sl0_46 0 1e-16
Cs0_46b slb0_46 0 1e-16
Xc0_46 sl0_46 slb0_46 ml0_46 0 0 tcam2f_frozen dvgl=0 dvgr=0
.ic v(xc0_46.xl.m)=0.424804359 v(xc0_46.xr.m)=-0.277154442
Cm0_46 ml0_46 0 1e-16
Rm0_46 ml0_46 ml0_47 3.2
Xd0_47a in_act sl0_47 vs0 sldrv
Xd0_47b vs0 slb0_47 vs0 sldrv
Cs0_47a sl0_47 0 1e-16
Cs0_47b slb0_47 0 1e-16
Xc0_47 sl0_47 slb0_47 ml0_47 0 0 tcam2f_frozen dvgl=0 dvgr=0
.ic v(xc0_47.xl.m)=0.424804359 v(xc0_47.xr.m)=-0.277154442
Cm0_47 ml0_47 0 1e-16
Rm0_47 ml0_47 ml0_48 3.2
Xd0_48a vs0 sl0_48 vs0 sldrv
Xd0_48b in_act slb0_48 vs0 sldrv
Cs0_48a sl0_48 0 1e-16
Cs0_48b slb0_48 0 1e-16
Xc0_48 sl0_48 slb0_48 ml0_48 0 0 tcam2f_frozen dvgl=0 dvgr=0
.ic v(xc0_48.xl.m)=-0.277154442 v(xc0_48.xr.m)=0.424804359
Cm0_48 ml0_48 0 1e-16
Rm0_48 ml0_48 ml0_49 3.2
Xd0_49a in_act sl0_49 vs0 sldrv
Xd0_49b vs0 slb0_49 vs0 sldrv
Cs0_49a sl0_49 0 1e-16
Cs0_49b slb0_49 0 1e-16
Xc0_49 sl0_49 slb0_49 ml0_49 0 0 tcam2f_frozen dvgl=0 dvgr=0
.ic v(xc0_49.xl.m)=0.424804359 v(xc0_49.xr.m)=-0.277154442
Cm0_49 ml0_49 0 1e-16
Rm0_49 ml0_49 ml0_50 3.2
Xd0_50a vs0 sl0_50 vs0 sldrv
Xd0_50b in_act slb0_50 vs0 sldrv
Cs0_50a sl0_50 0 1e-16
Cs0_50b slb0_50 0 1e-16
Xc0_50 sl0_50 slb0_50 ml0_50 0 0 tcam2f_frozen dvgl=0 dvgr=0
.ic v(xc0_50.xl.m)=-0.277154442 v(xc0_50.xr.m)=0.424804359
Cm0_50 ml0_50 0 1e-16
Rm0_50 ml0_50 ml0_51 3.2
Xd0_51a vs0 sl0_51 vs0 sldrv
Xd0_51b in_act slb0_51 vs0 sldrv
Cs0_51a sl0_51 0 1e-16
Cs0_51b slb0_51 0 1e-16
Xc0_51 sl0_51 slb0_51 ml0_51 0 0 tcam2f_frozen dvgl=0 dvgr=0
.ic v(xc0_51.xl.m)=-0.277154442 v(xc0_51.xr.m)=0.424804359
Cm0_51 ml0_51 0 1e-16
Rm0_51 ml0_51 ml0_52 3.2
Xd0_52a in_act sl0_52 vs0 sldrv
Xd0_52b vs0 slb0_52 vs0 sldrv
Cs0_52a sl0_52 0 1e-16
Cs0_52b slb0_52 0 1e-16
Xc0_52 sl0_52 slb0_52 ml0_52 0 0 tcam2f_frozen dvgl=0 dvgr=0
.ic v(xc0_52.xl.m)=0.424804359 v(xc0_52.xr.m)=-0.277154442
Cm0_52 ml0_52 0 1e-16
Rm0_52 ml0_52 ml0_53 3.2
Xd0_53a vs0 sl0_53 vs0 sldrv
Xd0_53b in_act slb0_53 vs0 sldrv
Cs0_53a sl0_53 0 1e-16
Cs0_53b slb0_53 0 1e-16
Xc0_53 sl0_53 slb0_53 ml0_53 0 0 tcam2f_frozen dvgl=0 dvgr=0
.ic v(xc0_53.xl.m)=-0.277154442 v(xc0_53.xr.m)=0.424804359
Cm0_53 ml0_53 0 1e-16
Rm0_53 ml0_53 ml0_54 3.2
Xd0_54a in_act sl0_54 vs0 sldrv
Xd0_54b vs0 slb0_54 vs0 sldrv
Cs0_54a sl0_54 0 1e-16
Cs0_54b slb0_54 0 1e-16
Xc0_54 sl0_54 slb0_54 ml0_54 0 0 tcam2f_frozen dvgl=0 dvgr=0
.ic v(xc0_54.xl.m)=0.424804359 v(xc0_54.xr.m)=-0.277154442
Cm0_54 ml0_54 0 1e-16
Rm0_54 ml0_54 ml0_55 3.2
Xd0_55a in_act sl0_55 vs0 sldrv
Xd0_55b vs0 slb0_55 vs0 sldrv
Cs0_55a sl0_55 0 1e-16
Cs0_55b slb0_55 0 1e-16
Xc0_55 sl0_55 slb0_55 ml0_55 0 0 tcam2f_frozen dvgl=0 dvgr=0
.ic v(xc0_55.xl.m)=0.424804359 v(xc0_55.xr.m)=-0.277154442
Cm0_55 ml0_55 0 1e-16
Rm0_55 ml0_55 ml0_56 3.2
Xd0_56a vs0 sl0_56 vs0 sldrv
Xd0_56b in_act slb0_56 vs0 sldrv
Cs0_56a sl0_56 0 1e-16
Cs0_56b slb0_56 0 1e-16
Xc0_56 sl0_56 slb0_56 ml0_56 0 0 tcam2f_frozen dvgl=0 dvgr=0
.ic v(xc0_56.xl.m)=-0.277154442 v(xc0_56.xr.m)=0.424804359
Cm0_56 ml0_56 0 1e-16
Rm0_56 ml0_56 ml0_57 3.2
Xd0_57a in_act sl0_57 vs0 sldrv
Xd0_57b vs0 slb0_57 vs0 sldrv
Cs0_57a sl0_57 0 1e-16
Cs0_57b slb0_57 0 1e-16
Xc0_57 sl0_57 slb0_57 ml0_57 0 0 tcam2f_frozen dvgl=0 dvgr=0
.ic v(xc0_57.xl.m)=0.424804359 v(xc0_57.xr.m)=-0.277154442
Cm0_57 ml0_57 0 1e-16
Rm0_57 ml0_57 ml0_58 3.2
Xd0_58a vs0 sl0_58 vs0 sldrv
Xd0_58b in_act slb0_58 vs0 sldrv
Cs0_58a sl0_58 0 1e-16
Cs0_58b slb0_58 0 1e-16
Xc0_58 sl0_58 slb0_58 ml0_58 0 0 tcam2f_frozen dvgl=0 dvgr=0
.ic v(xc0_58.xl.m)=-0.277154442 v(xc0_58.xr.m)=0.424804359
Cm0_58 ml0_58 0 1e-16
Rm0_58 ml0_58 ml0_59 3.2
Xd0_59a vs0 sl0_59 vs0 sldrv
Xd0_59b in_act slb0_59 vs0 sldrv
Cs0_59a sl0_59 0 1e-16
Cs0_59b slb0_59 0 1e-16
Xc0_59 sl0_59 slb0_59 ml0_59 0 0 tcam2f_frozen dvgl=0 dvgr=0
.ic v(xc0_59.xl.m)=-0.277154442 v(xc0_59.xr.m)=0.424804359
Cm0_59 ml0_59 0 1e-16
Rm0_59 ml0_59 ml0_60 3.2
Xd0_60a in_act sl0_60 vs0 sldrv
Xd0_60b vs0 slb0_60 vs0 sldrv
Cs0_60a sl0_60 0 1e-16
Cs0_60b slb0_60 0 1e-16
Xc0_60 sl0_60 slb0_60 ml0_60 0 0 tcam2f_frozen dvgl=0 dvgr=0
.ic v(xc0_60.xl.m)=0.424804359 v(xc0_60.xr.m)=-0.277154442
Cm0_60 ml0_60 0 1e-16
Rm0_60 ml0_60 ml0_61 3.2
Xd0_61a vs0 sl0_61 vs0 sldrv
Xd0_61b in_act slb0_61 vs0 sldrv
Cs0_61a sl0_61 0 1e-16
Cs0_61b slb0_61 0 1e-16
Xc0_61 sl0_61 slb0_61 ml0_61 0 0 tcam2f_frozen dvgl=0 dvgr=0
.ic v(xc0_61.xl.m)=-0.277154442 v(xc0_61.xr.m)=0.424804359
Cm0_61 ml0_61 0 1e-16
Rm0_61 ml0_61 ml0_62 3.2
Xd0_62a in_act sl0_62 vs0 sldrv
Xd0_62b vs0 slb0_62 vs0 sldrv
Cs0_62a sl0_62 0 1e-16
Cs0_62b slb0_62 0 1e-16
Xc0_62 sl0_62 slb0_62 ml0_62 0 0 tcam2f_frozen dvgl=0 dvgr=0
.ic v(xc0_62.xl.m)=0.424804359 v(xc0_62.xr.m)=-0.277154442
Cm0_62 ml0_62 0 1e-16
Rm0_62 ml0_62 ml0_63 3.2
Xd0_63a in_act sl0_63 vs0 sldrv
Xd0_63b vs0 slb0_63 vs0 sldrv
Cs0_63a sl0_63 0 1e-16
Cs0_63b slb0_63 0 1e-16
Xc0_63 sl0_63 slb0_63 ml0_63 0 0 tcam2f_frozen dvgl=0 dvgr=0
.ic v(xc0_63.xl.m)=0.424804359 v(xc0_63.xr.m)=-0.277154442
Cm0_63 ml0_63 0 1e-16
Xp0 ml0_0 preb vdd0 mlpre
Xsa0 ml0_0 miss0 match0 vdd0 mlsa
.ic v(ml0_0)=1.0 v(ml0_1)=1.0 v(ml0_2)=1.0 v(ml0_3)=1.0 v(ml0_4)=1.0 v(ml0_5)=1.0 v(ml0_6)=1.0 v(ml0_7)=1.0 v(ml0_8)=1.0 v(ml0_9)=1.0 v(ml0_10)=1.0 v(ml0_11)=1.0 v(ml0_12)=1.0 v(ml0_13)=1.0 v(ml0_14)=1.0 v(ml0_15)=1.0 v(ml0_16)=1.0 v(ml0_17)=1.0 v(ml0_18)=1.0 v(ml0_19)=1.0 v(ml0_20)=1.0 v(ml0_21)=1.0 v(ml0_22)=1.0 v(ml0_23)=1.0 v(ml0_24)=1.0 v(ml0_25)=1.0 v(ml0_26)=1.0 v(ml0_27)=1.0 v(ml0_28)=1.0 v(ml0_29)=1.0 v(ml0_30)=1.0 v(ml0_31)=1.0 v(ml0_32)=1.0 v(ml0_33)=1.0 v(ml0_34)=1.0 v(ml0_35)=1.0 v(ml0_36)=1.0 v(ml0_37)=1.0 v(ml0_38)=1.0 v(ml0_39)=1.0 v(ml0_40)=1.0 v(ml0_41)=1.0 v(ml0_42)=1.0 v(ml0_43)=1.0 v(ml0_44)=1.0 v(ml0_45)=1.0 v(ml0_46)=1.0 v(ml0_47)=1.0 v(ml0_48)=1.0 v(ml0_49)=1.0 v(ml0_50)=1.0 v(ml0_51)=1.0 v(ml0_52)=1.0 v(ml0_53)=1.0 v(ml0_54)=1.0 v(ml0_55)=1.0 v(ml0_56)=1.0 v(ml0_57)=1.0 v(ml0_58)=1.0 v(ml0_59)=1.0 v(ml0_60)=1.0 v(ml0_61)=1.0 v(ml0_62)=1.0 v(ml0_63)=1.0 v(match0)=1.0
.control
set wr_singlescale
set wr_vecnames
tran 1n 1.86e-08 0 5e-12 uic
wrdata sim/out/t3c/t3c_word64_m64.csv v(ml0_0) v(miss0) i(vdd0) i(vs0)
.endc
.end
