* t3a_read.cir -- generated by circuit/tcam/make_tcam.py read
* Test 3a: read every FeFET of the write and disturb decks (fresh instances from their
* saved states). r<row>c<cell><l|r>: array FeFETs; d<name>: disturb FeFETs.
.include ../../device/ngspice/fefet_preisach.lib
.options reltol=1e-4 abstol=1e-15 method=gear
Vg_r0c0l g_r0c0l 0 pwl(
+ 0 0 1e-06 0 2e-06 -0.2 2.2e-06 -0.18 2.4e-06 -0.16 2.6e-06 -0.14
+ 2.8e-06 -0.12 3e-06 -0.1 3.2e-06 -0.08 3.4e-06 -0.06 3.6e-06 -0.04 3.8e-06 -0.02
+ 4e-06 0 4.2e-06 0.02 4.4e-06 0.04 4.6e-06 0.06 4.8e-06 0.08 5e-06 0.1
+ 5.2e-06 0.12 5.4e-06 0.14 5.6e-06 0.16 5.8e-06 0.18 6e-06 0.2 6.2e-06 0.22
+ 6.4e-06 0.24 6.6e-06 0.26 6.8e-06 0.28 7e-06 0.3 7.2e-06 0.32 7.4e-06 0.34
+ 7.6e-06 0.36 7.8e-06 0.38 8e-06 0.4 8.2e-06 0.42 8.4e-06 0.44 8.6e-06 0.46
+ 8.8e-06 0.48 9e-06 0.5 9.2e-06 0.52 9.4e-06 0.54 9.6e-06 0.56 9.8e-06 0.58
+ 1e-05 0.6 1.02e-05 0.62 1.04e-05 0.64 1.06e-05 0.66 1.08e-05 0.68 1.1e-05 0.7
+ 1.12e-05 0.72 1.14e-05 0.74 1.16e-05 0.76 1.18e-05 0.78 1.2e-05 0.8 1.22e-05 0.82
+ 1.24e-05 0.84 1.26e-05 0.86 1.28e-05 0.88 1.3e-05 0.9 1.32e-05 0.92 1.34e-05 0.94
+ 1.36e-05 0.96 1.38e-05 0.98 1.4e-05 1 1.42e-05 1.02 1.44e-05 1.04 1.46e-05 1.06
+ 1.48e-05 1.08 1.5e-05 1.1 1.52e-05 1.12 1.54e-05 1.14 1.56e-05 1.16 1.58e-05 1.18
+ 1.6e-05 1.2 1.62e-05 1.22 1.64e-05 1.24 1.66e-05 1.26 1.68e-05 1.28 1.7e-05 1.3
+ 1.72e-05 1.32 1.74e-05 1.34 1.76e-05 1.36 1.78e-05 1.38 1.8e-05 1.4 1.82e-05 1.42
+ 1.84e-05 1.44 1.86e-05 1.46 1.88e-05 1.48 1.9e-05 1.5 1.92e-05 1.52 1.94e-05 1.54
+ 1.96e-05 1.56 1.98e-05 1.58 2e-05 1.6 2.02e-05 1.62 2.04e-05 1.64 2.06e-05 1.66
+ 2.08e-05 1.68 2.1e-05 1.7 2.12e-05 1.72 2.14e-05 1.74 2.16e-05 1.76 2.18e-05 1.78
+ 2.2e-05 1.8 2.22e-05 1.82 2.24e-05 1.84 2.26e-05 1.86 2.28e-05 1.88 2.3e-05 1.9
+ 2.32e-05 1.92 2.34e-05 1.94 2.36e-05 1.96 2.38e-05 1.98 2.4e-05 2 2.42e-05 2.02
+ 2.44e-05 2.04 2.46e-05 2.06 2.48e-05 2.08 2.5e-05 2.1 2.52e-05 2.12 2.54e-05 2.14
+ 2.56e-05 2.16 2.58e-05 2.18 2.6e-05 2.2 2.62e-05 2.22 2.64e-05 2.24 2.66e-05 2.26
+ 2.68e-05 2.28 2.7e-05 2.3 2.72e-05 2.32 2.74e-05 2.34 2.76e-05 2.36 2.78e-05 2.38
+ 2.8e-05 2.4 2.9e-05 0)
Vd_r0c0l d_r0c0l 0 pwl(
+ 0 0 4e-07 0 5e-07 0.05 2.91e-05 0.05 2.92e-05 0)
Xr0c0l g_r0c0l d_r0c0l 0 0 fefet_c16 x0_1=-1 x0_2=-1 x0_3=-1 x0_4=-1 x0_5=-1 x0_6=-1
+ x0_7=-1 x0_8=-1 x0_9=-1 x0_10=-1 x0_11=-1 x0_12=-1
+ x0_13=-1 x0_14=-1 x0_15=-1 x0_16=-1
.ic v(xr0c0l.m)=-0.277157633
Vg_r0c0r g_r0c0r 0 pwl(
+ 0 0 1e-06 0 2e-06 -0.2 2.2e-06 -0.18 2.4e-06 -0.16 2.6e-06 -0.14
+ 2.8e-06 -0.12 3e-06 -0.1 3.2e-06 -0.08 3.4e-06 -0.06 3.6e-06 -0.04 3.8e-06 -0.02
+ 4e-06 0 4.2e-06 0.02 4.4e-06 0.04 4.6e-06 0.06 4.8e-06 0.08 5e-06 0.1
+ 5.2e-06 0.12 5.4e-06 0.14 5.6e-06 0.16 5.8e-06 0.18 6e-06 0.2 6.2e-06 0.22
+ 6.4e-06 0.24 6.6e-06 0.26 6.8e-06 0.28 7e-06 0.3 7.2e-06 0.32 7.4e-06 0.34
+ 7.6e-06 0.36 7.8e-06 0.38 8e-06 0.4 8.2e-06 0.42 8.4e-06 0.44 8.6e-06 0.46
+ 8.8e-06 0.48 9e-06 0.5 9.2e-06 0.52 9.4e-06 0.54 9.6e-06 0.56 9.8e-06 0.58
+ 1e-05 0.6 1.02e-05 0.62 1.04e-05 0.64 1.06e-05 0.66 1.08e-05 0.68 1.1e-05 0.7
+ 1.12e-05 0.72 1.14e-05 0.74 1.16e-05 0.76 1.18e-05 0.78 1.2e-05 0.8 1.22e-05 0.82
+ 1.24e-05 0.84 1.26e-05 0.86 1.28e-05 0.88 1.3e-05 0.9 1.32e-05 0.92 1.34e-05 0.94
+ 1.36e-05 0.96 1.38e-05 0.98 1.4e-05 1 1.42e-05 1.02 1.44e-05 1.04 1.46e-05 1.06
+ 1.48e-05 1.08 1.5e-05 1.1 1.52e-05 1.12 1.54e-05 1.14 1.56e-05 1.16 1.58e-05 1.18
+ 1.6e-05 1.2 1.62e-05 1.22 1.64e-05 1.24 1.66e-05 1.26 1.68e-05 1.28 1.7e-05 1.3
+ 1.72e-05 1.32 1.74e-05 1.34 1.76e-05 1.36 1.78e-05 1.38 1.8e-05 1.4 1.82e-05 1.42
+ 1.84e-05 1.44 1.86e-05 1.46 1.88e-05 1.48 1.9e-05 1.5 1.92e-05 1.52 1.94e-05 1.54
+ 1.96e-05 1.56 1.98e-05 1.58 2e-05 1.6 2.02e-05 1.62 2.04e-05 1.64 2.06e-05 1.66
+ 2.08e-05 1.68 2.1e-05 1.7 2.12e-05 1.72 2.14e-05 1.74 2.16e-05 1.76 2.18e-05 1.78
+ 2.2e-05 1.8 2.22e-05 1.82 2.24e-05 1.84 2.26e-05 1.86 2.28e-05 1.88 2.3e-05 1.9
+ 2.32e-05 1.92 2.34e-05 1.94 2.36e-05 1.96 2.38e-05 1.98 2.4e-05 2 2.42e-05 2.02
+ 2.44e-05 2.04 2.46e-05 2.06 2.48e-05 2.08 2.5e-05 2.1 2.52e-05 2.12 2.54e-05 2.14
+ 2.56e-05 2.16 2.58e-05 2.18 2.6e-05 2.2 2.62e-05 2.22 2.64e-05 2.24 2.66e-05 2.26
+ 2.68e-05 2.28 2.7e-05 2.3 2.72e-05 2.32 2.74e-05 2.34 2.76e-05 2.36 2.78e-05 2.38
+ 2.8e-05 2.4 2.9e-05 0)
Vd_r0c0r d_r0c0r 0 pwl(
+ 0 0 4e-07 0 5e-07 0.05 2.91e-05 0.05 2.92e-05 0)
Xr0c0r g_r0c0r d_r0c0r 0 0 fefet_c16 x0_1=0.999999999 x0_2=0.999999981 x0_3=0.999999958 x0_4=0.999999968 x0_5=1.00000008 x0_6=1.00000039
+ x0_7=1.00000101 x0_8=1.00000201 x0_9=1.00000329 x0_10=1.00000414 x0_11=1.00000239 x0_12=0.999992197
+ x0_13=0.999959838 x0_14=0.99988151 x0_15=0.999818708 x0_16=1.00239255
.ic v(xr0c0r.m)=0.424867794
Vg_r0c1l g_r0c1l 0 pwl(
+ 0 0 1e-06 0 2e-06 -0.2 2.2e-06 -0.18 2.4e-06 -0.16 2.6e-06 -0.14
+ 2.8e-06 -0.12 3e-06 -0.1 3.2e-06 -0.08 3.4e-06 -0.06 3.6e-06 -0.04 3.8e-06 -0.02
+ 4e-06 0 4.2e-06 0.02 4.4e-06 0.04 4.6e-06 0.06 4.8e-06 0.08 5e-06 0.1
+ 5.2e-06 0.12 5.4e-06 0.14 5.6e-06 0.16 5.8e-06 0.18 6e-06 0.2 6.2e-06 0.22
+ 6.4e-06 0.24 6.6e-06 0.26 6.8e-06 0.28 7e-06 0.3 7.2e-06 0.32 7.4e-06 0.34
+ 7.6e-06 0.36 7.8e-06 0.38 8e-06 0.4 8.2e-06 0.42 8.4e-06 0.44 8.6e-06 0.46
+ 8.8e-06 0.48 9e-06 0.5 9.2e-06 0.52 9.4e-06 0.54 9.6e-06 0.56 9.8e-06 0.58
+ 1e-05 0.6 1.02e-05 0.62 1.04e-05 0.64 1.06e-05 0.66 1.08e-05 0.68 1.1e-05 0.7
+ 1.12e-05 0.72 1.14e-05 0.74 1.16e-05 0.76 1.18e-05 0.78 1.2e-05 0.8 1.22e-05 0.82
+ 1.24e-05 0.84 1.26e-05 0.86 1.28e-05 0.88 1.3e-05 0.9 1.32e-05 0.92 1.34e-05 0.94
+ 1.36e-05 0.96 1.38e-05 0.98 1.4e-05 1 1.42e-05 1.02 1.44e-05 1.04 1.46e-05 1.06
+ 1.48e-05 1.08 1.5e-05 1.1 1.52e-05 1.12 1.54e-05 1.14 1.56e-05 1.16 1.58e-05 1.18
+ 1.6e-05 1.2 1.62e-05 1.22 1.64e-05 1.24 1.66e-05 1.26 1.68e-05 1.28 1.7e-05 1.3
+ 1.72e-05 1.32 1.74e-05 1.34 1.76e-05 1.36 1.78e-05 1.38 1.8e-05 1.4 1.82e-05 1.42
+ 1.84e-05 1.44 1.86e-05 1.46 1.88e-05 1.48 1.9e-05 1.5 1.92e-05 1.52 1.94e-05 1.54
+ 1.96e-05 1.56 1.98e-05 1.58 2e-05 1.6 2.02e-05 1.62 2.04e-05 1.64 2.06e-05 1.66
+ 2.08e-05 1.68 2.1e-05 1.7 2.12e-05 1.72 2.14e-05 1.74 2.16e-05 1.76 2.18e-05 1.78
+ 2.2e-05 1.8 2.22e-05 1.82 2.24e-05 1.84 2.26e-05 1.86 2.28e-05 1.88 2.3e-05 1.9
+ 2.32e-05 1.92 2.34e-05 1.94 2.36e-05 1.96 2.38e-05 1.98 2.4e-05 2 2.42e-05 2.02
+ 2.44e-05 2.04 2.46e-05 2.06 2.48e-05 2.08 2.5e-05 2.1 2.52e-05 2.12 2.54e-05 2.14
+ 2.56e-05 2.16 2.58e-05 2.18 2.6e-05 2.2 2.62e-05 2.22 2.64e-05 2.24 2.66e-05 2.26
+ 2.68e-05 2.28 2.7e-05 2.3 2.72e-05 2.32 2.74e-05 2.34 2.76e-05 2.36 2.78e-05 2.38
+ 2.8e-05 2.4 2.9e-05 0)
Vd_r0c1l d_r0c1l 0 pwl(
+ 0 0 4e-07 0 5e-07 0.05 2.91e-05 0.05 2.92e-05 0)
Xr0c1l g_r0c1l d_r0c1l 0 0 fefet_c16 x0_1=0.999999999 x0_2=0.999999981 x0_3=0.999999958 x0_4=0.999999968 x0_5=1.00000008 x0_6=1.00000039
+ x0_7=1.00000101 x0_8=1.00000201 x0_9=1.00000329 x0_10=1.00000414 x0_11=1.00000239 x0_12=0.999992197
+ x0_13=0.999959838 x0_14=0.99988151 x0_15=0.999818708 x0_16=1.00239255
.ic v(xr0c1l.m)=0.424867794
Vg_r0c1r g_r0c1r 0 pwl(
+ 0 0 1e-06 0 2e-06 -0.2 2.2e-06 -0.18 2.4e-06 -0.16 2.6e-06 -0.14
+ 2.8e-06 -0.12 3e-06 -0.1 3.2e-06 -0.08 3.4e-06 -0.06 3.6e-06 -0.04 3.8e-06 -0.02
+ 4e-06 0 4.2e-06 0.02 4.4e-06 0.04 4.6e-06 0.06 4.8e-06 0.08 5e-06 0.1
+ 5.2e-06 0.12 5.4e-06 0.14 5.6e-06 0.16 5.8e-06 0.18 6e-06 0.2 6.2e-06 0.22
+ 6.4e-06 0.24 6.6e-06 0.26 6.8e-06 0.28 7e-06 0.3 7.2e-06 0.32 7.4e-06 0.34
+ 7.6e-06 0.36 7.8e-06 0.38 8e-06 0.4 8.2e-06 0.42 8.4e-06 0.44 8.6e-06 0.46
+ 8.8e-06 0.48 9e-06 0.5 9.2e-06 0.52 9.4e-06 0.54 9.6e-06 0.56 9.8e-06 0.58
+ 1e-05 0.6 1.02e-05 0.62 1.04e-05 0.64 1.06e-05 0.66 1.08e-05 0.68 1.1e-05 0.7
+ 1.12e-05 0.72 1.14e-05 0.74 1.16e-05 0.76 1.18e-05 0.78 1.2e-05 0.8 1.22e-05 0.82
+ 1.24e-05 0.84 1.26e-05 0.86 1.28e-05 0.88 1.3e-05 0.9 1.32e-05 0.92 1.34e-05 0.94
+ 1.36e-05 0.96 1.38e-05 0.98 1.4e-05 1 1.42e-05 1.02 1.44e-05 1.04 1.46e-05 1.06
+ 1.48e-05 1.08 1.5e-05 1.1 1.52e-05 1.12 1.54e-05 1.14 1.56e-05 1.16 1.58e-05 1.18
+ 1.6e-05 1.2 1.62e-05 1.22 1.64e-05 1.24 1.66e-05 1.26 1.68e-05 1.28 1.7e-05 1.3
+ 1.72e-05 1.32 1.74e-05 1.34 1.76e-05 1.36 1.78e-05 1.38 1.8e-05 1.4 1.82e-05 1.42
+ 1.84e-05 1.44 1.86e-05 1.46 1.88e-05 1.48 1.9e-05 1.5 1.92e-05 1.52 1.94e-05 1.54
+ 1.96e-05 1.56 1.98e-05 1.58 2e-05 1.6 2.02e-05 1.62 2.04e-05 1.64 2.06e-05 1.66
+ 2.08e-05 1.68 2.1e-05 1.7 2.12e-05 1.72 2.14e-05 1.74 2.16e-05 1.76 2.18e-05 1.78
+ 2.2e-05 1.8 2.22e-05 1.82 2.24e-05 1.84 2.26e-05 1.86 2.28e-05 1.88 2.3e-05 1.9
+ 2.32e-05 1.92 2.34e-05 1.94 2.36e-05 1.96 2.38e-05 1.98 2.4e-05 2 2.42e-05 2.02
+ 2.44e-05 2.04 2.46e-05 2.06 2.48e-05 2.08 2.5e-05 2.1 2.52e-05 2.12 2.54e-05 2.14
+ 2.56e-05 2.16 2.58e-05 2.18 2.6e-05 2.2 2.62e-05 2.22 2.64e-05 2.24 2.66e-05 2.26
+ 2.68e-05 2.28 2.7e-05 2.3 2.72e-05 2.32 2.74e-05 2.34 2.76e-05 2.36 2.78e-05 2.38
+ 2.8e-05 2.4 2.9e-05 0)
Vd_r0c1r d_r0c1r 0 pwl(
+ 0 0 4e-07 0 5e-07 0.05 2.91e-05 0.05 2.92e-05 0)
Xr0c1r g_r0c1r d_r0c1r 0 0 fefet_c16 x0_1=-1 x0_2=-1 x0_3=-1 x0_4=-1 x0_5=-1 x0_6=-1
+ x0_7=-1 x0_8=-1 x0_9=-1 x0_10=-1 x0_11=-1 x0_12=-1
+ x0_13=-1 x0_14=-1 x0_15=-1 x0_16=-1
.ic v(xr0c1r.m)=-0.277157633
Vg_r0c2l g_r0c2l 0 pwl(
+ 0 0 1e-06 0 2e-06 -0.2 2.2e-06 -0.18 2.4e-06 -0.16 2.6e-06 -0.14
+ 2.8e-06 -0.12 3e-06 -0.1 3.2e-06 -0.08 3.4e-06 -0.06 3.6e-06 -0.04 3.8e-06 -0.02
+ 4e-06 0 4.2e-06 0.02 4.4e-06 0.04 4.6e-06 0.06 4.8e-06 0.08 5e-06 0.1
+ 5.2e-06 0.12 5.4e-06 0.14 5.6e-06 0.16 5.8e-06 0.18 6e-06 0.2 6.2e-06 0.22
+ 6.4e-06 0.24 6.6e-06 0.26 6.8e-06 0.28 7e-06 0.3 7.2e-06 0.32 7.4e-06 0.34
+ 7.6e-06 0.36 7.8e-06 0.38 8e-06 0.4 8.2e-06 0.42 8.4e-06 0.44 8.6e-06 0.46
+ 8.8e-06 0.48 9e-06 0.5 9.2e-06 0.52 9.4e-06 0.54 9.6e-06 0.56 9.8e-06 0.58
+ 1e-05 0.6 1.02e-05 0.62 1.04e-05 0.64 1.06e-05 0.66 1.08e-05 0.68 1.1e-05 0.7
+ 1.12e-05 0.72 1.14e-05 0.74 1.16e-05 0.76 1.18e-05 0.78 1.2e-05 0.8 1.22e-05 0.82
+ 1.24e-05 0.84 1.26e-05 0.86 1.28e-05 0.88 1.3e-05 0.9 1.32e-05 0.92 1.34e-05 0.94
+ 1.36e-05 0.96 1.38e-05 0.98 1.4e-05 1 1.42e-05 1.02 1.44e-05 1.04 1.46e-05 1.06
+ 1.48e-05 1.08 1.5e-05 1.1 1.52e-05 1.12 1.54e-05 1.14 1.56e-05 1.16 1.58e-05 1.18
+ 1.6e-05 1.2 1.62e-05 1.22 1.64e-05 1.24 1.66e-05 1.26 1.68e-05 1.28 1.7e-05 1.3
+ 1.72e-05 1.32 1.74e-05 1.34 1.76e-05 1.36 1.78e-05 1.38 1.8e-05 1.4 1.82e-05 1.42
+ 1.84e-05 1.44 1.86e-05 1.46 1.88e-05 1.48 1.9e-05 1.5 1.92e-05 1.52 1.94e-05 1.54
+ 1.96e-05 1.56 1.98e-05 1.58 2e-05 1.6 2.02e-05 1.62 2.04e-05 1.64 2.06e-05 1.66
+ 2.08e-05 1.68 2.1e-05 1.7 2.12e-05 1.72 2.14e-05 1.74 2.16e-05 1.76 2.18e-05 1.78
+ 2.2e-05 1.8 2.22e-05 1.82 2.24e-05 1.84 2.26e-05 1.86 2.28e-05 1.88 2.3e-05 1.9
+ 2.32e-05 1.92 2.34e-05 1.94 2.36e-05 1.96 2.38e-05 1.98 2.4e-05 2 2.42e-05 2.02
+ 2.44e-05 2.04 2.46e-05 2.06 2.48e-05 2.08 2.5e-05 2.1 2.52e-05 2.12 2.54e-05 2.14
+ 2.56e-05 2.16 2.58e-05 2.18 2.6e-05 2.2 2.62e-05 2.22 2.64e-05 2.24 2.66e-05 2.26
+ 2.68e-05 2.28 2.7e-05 2.3 2.72e-05 2.32 2.74e-05 2.34 2.76e-05 2.36 2.78e-05 2.38
+ 2.8e-05 2.4 2.9e-05 0)
Vd_r0c2l d_r0c2l 0 pwl(
+ 0 0 4e-07 0 5e-07 0.05 2.91e-05 0.05 2.92e-05 0)
Xr0c2l g_r0c2l d_r0c2l 0 0 fefet_c16 x0_1=-1 x0_2=-1 x0_3=-1 x0_4=-1 x0_5=-1 x0_6=-1
+ x0_7=-1 x0_8=-1 x0_9=-1 x0_10=-1 x0_11=-1 x0_12=-1
+ x0_13=-1 x0_14=-1 x0_15=-1 x0_16=-1
.ic v(xr0c2l.m)=-0.277157633
Vg_r0c2r g_r0c2r 0 pwl(
+ 0 0 1e-06 0 2e-06 -0.2 2.2e-06 -0.18 2.4e-06 -0.16 2.6e-06 -0.14
+ 2.8e-06 -0.12 3e-06 -0.1 3.2e-06 -0.08 3.4e-06 -0.06 3.6e-06 -0.04 3.8e-06 -0.02
+ 4e-06 0 4.2e-06 0.02 4.4e-06 0.04 4.6e-06 0.06 4.8e-06 0.08 5e-06 0.1
+ 5.2e-06 0.12 5.4e-06 0.14 5.6e-06 0.16 5.8e-06 0.18 6e-06 0.2 6.2e-06 0.22
+ 6.4e-06 0.24 6.6e-06 0.26 6.8e-06 0.28 7e-06 0.3 7.2e-06 0.32 7.4e-06 0.34
+ 7.6e-06 0.36 7.8e-06 0.38 8e-06 0.4 8.2e-06 0.42 8.4e-06 0.44 8.6e-06 0.46
+ 8.8e-06 0.48 9e-06 0.5 9.2e-06 0.52 9.4e-06 0.54 9.6e-06 0.56 9.8e-06 0.58
+ 1e-05 0.6 1.02e-05 0.62 1.04e-05 0.64 1.06e-05 0.66 1.08e-05 0.68 1.1e-05 0.7
+ 1.12e-05 0.72 1.14e-05 0.74 1.16e-05 0.76 1.18e-05 0.78 1.2e-05 0.8 1.22e-05 0.82
+ 1.24e-05 0.84 1.26e-05 0.86 1.28e-05 0.88 1.3e-05 0.9 1.32e-05 0.92 1.34e-05 0.94
+ 1.36e-05 0.96 1.38e-05 0.98 1.4e-05 1 1.42e-05 1.02 1.44e-05 1.04 1.46e-05 1.06
+ 1.48e-05 1.08 1.5e-05 1.1 1.52e-05 1.12 1.54e-05 1.14 1.56e-05 1.16 1.58e-05 1.18
+ 1.6e-05 1.2 1.62e-05 1.22 1.64e-05 1.24 1.66e-05 1.26 1.68e-05 1.28 1.7e-05 1.3
+ 1.72e-05 1.32 1.74e-05 1.34 1.76e-05 1.36 1.78e-05 1.38 1.8e-05 1.4 1.82e-05 1.42
+ 1.84e-05 1.44 1.86e-05 1.46 1.88e-05 1.48 1.9e-05 1.5 1.92e-05 1.52 1.94e-05 1.54
+ 1.96e-05 1.56 1.98e-05 1.58 2e-05 1.6 2.02e-05 1.62 2.04e-05 1.64 2.06e-05 1.66
+ 2.08e-05 1.68 2.1e-05 1.7 2.12e-05 1.72 2.14e-05 1.74 2.16e-05 1.76 2.18e-05 1.78
+ 2.2e-05 1.8 2.22e-05 1.82 2.24e-05 1.84 2.26e-05 1.86 2.28e-05 1.88 2.3e-05 1.9
+ 2.32e-05 1.92 2.34e-05 1.94 2.36e-05 1.96 2.38e-05 1.98 2.4e-05 2 2.42e-05 2.02
+ 2.44e-05 2.04 2.46e-05 2.06 2.48e-05 2.08 2.5e-05 2.1 2.52e-05 2.12 2.54e-05 2.14
+ 2.56e-05 2.16 2.58e-05 2.18 2.6e-05 2.2 2.62e-05 2.22 2.64e-05 2.24 2.66e-05 2.26
+ 2.68e-05 2.28 2.7e-05 2.3 2.72e-05 2.32 2.74e-05 2.34 2.76e-05 2.36 2.78e-05 2.38
+ 2.8e-05 2.4 2.9e-05 0)
Vd_r0c2r d_r0c2r 0 pwl(
+ 0 0 4e-07 0 5e-07 0.05 2.91e-05 0.05 2.92e-05 0)
Xr0c2r g_r0c2r d_r0c2r 0 0 fefet_c16 x0_1=0.999999999 x0_2=0.999999981 x0_3=0.999999958 x0_4=0.999999968 x0_5=1.00000008 x0_6=1.00000039
+ x0_7=1.00000101 x0_8=1.00000201 x0_9=1.00000329 x0_10=1.00000414 x0_11=1.00000239 x0_12=0.999992197
+ x0_13=0.999959838 x0_14=0.99988151 x0_15=0.999818708 x0_16=1.00239255
.ic v(xr0c2r.m)=0.424867794
Vg_r0c3l g_r0c3l 0 pwl(
+ 0 0 1e-06 0 2e-06 -0.2 2.2e-06 -0.18 2.4e-06 -0.16 2.6e-06 -0.14
+ 2.8e-06 -0.12 3e-06 -0.1 3.2e-06 -0.08 3.4e-06 -0.06 3.6e-06 -0.04 3.8e-06 -0.02
+ 4e-06 0 4.2e-06 0.02 4.4e-06 0.04 4.6e-06 0.06 4.8e-06 0.08 5e-06 0.1
+ 5.2e-06 0.12 5.4e-06 0.14 5.6e-06 0.16 5.8e-06 0.18 6e-06 0.2 6.2e-06 0.22
+ 6.4e-06 0.24 6.6e-06 0.26 6.8e-06 0.28 7e-06 0.3 7.2e-06 0.32 7.4e-06 0.34
+ 7.6e-06 0.36 7.8e-06 0.38 8e-06 0.4 8.2e-06 0.42 8.4e-06 0.44 8.6e-06 0.46
+ 8.8e-06 0.48 9e-06 0.5 9.2e-06 0.52 9.4e-06 0.54 9.6e-06 0.56 9.8e-06 0.58
+ 1e-05 0.6 1.02e-05 0.62 1.04e-05 0.64 1.06e-05 0.66 1.08e-05 0.68 1.1e-05 0.7
+ 1.12e-05 0.72 1.14e-05 0.74 1.16e-05 0.76 1.18e-05 0.78 1.2e-05 0.8 1.22e-05 0.82
+ 1.24e-05 0.84 1.26e-05 0.86 1.28e-05 0.88 1.3e-05 0.9 1.32e-05 0.92 1.34e-05 0.94
+ 1.36e-05 0.96 1.38e-05 0.98 1.4e-05 1 1.42e-05 1.02 1.44e-05 1.04 1.46e-05 1.06
+ 1.48e-05 1.08 1.5e-05 1.1 1.52e-05 1.12 1.54e-05 1.14 1.56e-05 1.16 1.58e-05 1.18
+ 1.6e-05 1.2 1.62e-05 1.22 1.64e-05 1.24 1.66e-05 1.26 1.68e-05 1.28 1.7e-05 1.3
+ 1.72e-05 1.32 1.74e-05 1.34 1.76e-05 1.36 1.78e-05 1.38 1.8e-05 1.4 1.82e-05 1.42
+ 1.84e-05 1.44 1.86e-05 1.46 1.88e-05 1.48 1.9e-05 1.5 1.92e-05 1.52 1.94e-05 1.54
+ 1.96e-05 1.56 1.98e-05 1.58 2e-05 1.6 2.02e-05 1.62 2.04e-05 1.64 2.06e-05 1.66
+ 2.08e-05 1.68 2.1e-05 1.7 2.12e-05 1.72 2.14e-05 1.74 2.16e-05 1.76 2.18e-05 1.78
+ 2.2e-05 1.8 2.22e-05 1.82 2.24e-05 1.84 2.26e-05 1.86 2.28e-05 1.88 2.3e-05 1.9
+ 2.32e-05 1.92 2.34e-05 1.94 2.36e-05 1.96 2.38e-05 1.98 2.4e-05 2 2.42e-05 2.02
+ 2.44e-05 2.04 2.46e-05 2.06 2.48e-05 2.08 2.5e-05 2.1 2.52e-05 2.12 2.54e-05 2.14
+ 2.56e-05 2.16 2.58e-05 2.18 2.6e-05 2.2 2.62e-05 2.22 2.64e-05 2.24 2.66e-05 2.26
+ 2.68e-05 2.28 2.7e-05 2.3 2.72e-05 2.32 2.74e-05 2.34 2.76e-05 2.36 2.78e-05 2.38
+ 2.8e-05 2.4 2.9e-05 0)
Vd_r0c3l d_r0c3l 0 pwl(
+ 0 0 4e-07 0 5e-07 0.05 2.91e-05 0.05 2.92e-05 0)
Xr0c3l g_r0c3l d_r0c3l 0 0 fefet_c16 x0_1=-1 x0_2=-1 x0_3=-1 x0_4=-1 x0_5=-1 x0_6=-1
+ x0_7=-1 x0_8=-1 x0_9=-1 x0_10=-1 x0_11=-1 x0_12=-1
+ x0_13=-1 x0_14=-1 x0_15=-1 x0_16=-1
.ic v(xr0c3l.m)=-0.277157633
Vg_r0c3r g_r0c3r 0 pwl(
+ 0 0 1e-06 0 2e-06 -0.2 2.2e-06 -0.18 2.4e-06 -0.16 2.6e-06 -0.14
+ 2.8e-06 -0.12 3e-06 -0.1 3.2e-06 -0.08 3.4e-06 -0.06 3.6e-06 -0.04 3.8e-06 -0.02
+ 4e-06 0 4.2e-06 0.02 4.4e-06 0.04 4.6e-06 0.06 4.8e-06 0.08 5e-06 0.1
+ 5.2e-06 0.12 5.4e-06 0.14 5.6e-06 0.16 5.8e-06 0.18 6e-06 0.2 6.2e-06 0.22
+ 6.4e-06 0.24 6.6e-06 0.26 6.8e-06 0.28 7e-06 0.3 7.2e-06 0.32 7.4e-06 0.34
+ 7.6e-06 0.36 7.8e-06 0.38 8e-06 0.4 8.2e-06 0.42 8.4e-06 0.44 8.6e-06 0.46
+ 8.8e-06 0.48 9e-06 0.5 9.2e-06 0.52 9.4e-06 0.54 9.6e-06 0.56 9.8e-06 0.58
+ 1e-05 0.6 1.02e-05 0.62 1.04e-05 0.64 1.06e-05 0.66 1.08e-05 0.68 1.1e-05 0.7
+ 1.12e-05 0.72 1.14e-05 0.74 1.16e-05 0.76 1.18e-05 0.78 1.2e-05 0.8 1.22e-05 0.82
+ 1.24e-05 0.84 1.26e-05 0.86 1.28e-05 0.88 1.3e-05 0.9 1.32e-05 0.92 1.34e-05 0.94
+ 1.36e-05 0.96 1.38e-05 0.98 1.4e-05 1 1.42e-05 1.02 1.44e-05 1.04 1.46e-05 1.06
+ 1.48e-05 1.08 1.5e-05 1.1 1.52e-05 1.12 1.54e-05 1.14 1.56e-05 1.16 1.58e-05 1.18
+ 1.6e-05 1.2 1.62e-05 1.22 1.64e-05 1.24 1.66e-05 1.26 1.68e-05 1.28 1.7e-05 1.3
+ 1.72e-05 1.32 1.74e-05 1.34 1.76e-05 1.36 1.78e-05 1.38 1.8e-05 1.4 1.82e-05 1.42
+ 1.84e-05 1.44 1.86e-05 1.46 1.88e-05 1.48 1.9e-05 1.5 1.92e-05 1.52 1.94e-05 1.54
+ 1.96e-05 1.56 1.98e-05 1.58 2e-05 1.6 2.02e-05 1.62 2.04e-05 1.64 2.06e-05 1.66
+ 2.08e-05 1.68 2.1e-05 1.7 2.12e-05 1.72 2.14e-05 1.74 2.16e-05 1.76 2.18e-05 1.78
+ 2.2e-05 1.8 2.22e-05 1.82 2.24e-05 1.84 2.26e-05 1.86 2.28e-05 1.88 2.3e-05 1.9
+ 2.32e-05 1.92 2.34e-05 1.94 2.36e-05 1.96 2.38e-05 1.98 2.4e-05 2 2.42e-05 2.02
+ 2.44e-05 2.04 2.46e-05 2.06 2.48e-05 2.08 2.5e-05 2.1 2.52e-05 2.12 2.54e-05 2.14
+ 2.56e-05 2.16 2.58e-05 2.18 2.6e-05 2.2 2.62e-05 2.22 2.64e-05 2.24 2.66e-05 2.26
+ 2.68e-05 2.28 2.7e-05 2.3 2.72e-05 2.32 2.74e-05 2.34 2.76e-05 2.36 2.78e-05 2.38
+ 2.8e-05 2.4 2.9e-05 0)
Vd_r0c3r d_r0c3r 0 pwl(
+ 0 0 4e-07 0 5e-07 0.05 2.91e-05 0.05 2.92e-05 0)
Xr0c3r g_r0c3r d_r0c3r 0 0 fefet_c16 x0_1=0.999999999 x0_2=0.999999981 x0_3=0.999999958 x0_4=0.999999968 x0_5=1.00000008 x0_6=1.00000039
+ x0_7=1.00000101 x0_8=1.00000201 x0_9=1.00000329 x0_10=1.00000414 x0_11=1.00000239 x0_12=0.999992197
+ x0_13=0.999959838 x0_14=0.99988151 x0_15=0.999818708 x0_16=1.00239255
.ic v(xr0c3r.m)=0.424867794
Vg_r0c4l g_r0c4l 0 pwl(
+ 0 0 1e-06 0 2e-06 -0.2 2.2e-06 -0.18 2.4e-06 -0.16 2.6e-06 -0.14
+ 2.8e-06 -0.12 3e-06 -0.1 3.2e-06 -0.08 3.4e-06 -0.06 3.6e-06 -0.04 3.8e-06 -0.02
+ 4e-06 0 4.2e-06 0.02 4.4e-06 0.04 4.6e-06 0.06 4.8e-06 0.08 5e-06 0.1
+ 5.2e-06 0.12 5.4e-06 0.14 5.6e-06 0.16 5.8e-06 0.18 6e-06 0.2 6.2e-06 0.22
+ 6.4e-06 0.24 6.6e-06 0.26 6.8e-06 0.28 7e-06 0.3 7.2e-06 0.32 7.4e-06 0.34
+ 7.6e-06 0.36 7.8e-06 0.38 8e-06 0.4 8.2e-06 0.42 8.4e-06 0.44 8.6e-06 0.46
+ 8.8e-06 0.48 9e-06 0.5 9.2e-06 0.52 9.4e-06 0.54 9.6e-06 0.56 9.8e-06 0.58
+ 1e-05 0.6 1.02e-05 0.62 1.04e-05 0.64 1.06e-05 0.66 1.08e-05 0.68 1.1e-05 0.7
+ 1.12e-05 0.72 1.14e-05 0.74 1.16e-05 0.76 1.18e-05 0.78 1.2e-05 0.8 1.22e-05 0.82
+ 1.24e-05 0.84 1.26e-05 0.86 1.28e-05 0.88 1.3e-05 0.9 1.32e-05 0.92 1.34e-05 0.94
+ 1.36e-05 0.96 1.38e-05 0.98 1.4e-05 1 1.42e-05 1.02 1.44e-05 1.04 1.46e-05 1.06
+ 1.48e-05 1.08 1.5e-05 1.1 1.52e-05 1.12 1.54e-05 1.14 1.56e-05 1.16 1.58e-05 1.18
+ 1.6e-05 1.2 1.62e-05 1.22 1.64e-05 1.24 1.66e-05 1.26 1.68e-05 1.28 1.7e-05 1.3
+ 1.72e-05 1.32 1.74e-05 1.34 1.76e-05 1.36 1.78e-05 1.38 1.8e-05 1.4 1.82e-05 1.42
+ 1.84e-05 1.44 1.86e-05 1.46 1.88e-05 1.48 1.9e-05 1.5 1.92e-05 1.52 1.94e-05 1.54
+ 1.96e-05 1.56 1.98e-05 1.58 2e-05 1.6 2.02e-05 1.62 2.04e-05 1.64 2.06e-05 1.66
+ 2.08e-05 1.68 2.1e-05 1.7 2.12e-05 1.72 2.14e-05 1.74 2.16e-05 1.76 2.18e-05 1.78
+ 2.2e-05 1.8 2.22e-05 1.82 2.24e-05 1.84 2.26e-05 1.86 2.28e-05 1.88 2.3e-05 1.9
+ 2.32e-05 1.92 2.34e-05 1.94 2.36e-05 1.96 2.38e-05 1.98 2.4e-05 2 2.42e-05 2.02
+ 2.44e-05 2.04 2.46e-05 2.06 2.48e-05 2.08 2.5e-05 2.1 2.52e-05 2.12 2.54e-05 2.14
+ 2.56e-05 2.16 2.58e-05 2.18 2.6e-05 2.2 2.62e-05 2.22 2.64e-05 2.24 2.66e-05 2.26
+ 2.68e-05 2.28 2.7e-05 2.3 2.72e-05 2.32 2.74e-05 2.34 2.76e-05 2.36 2.78e-05 2.38
+ 2.8e-05 2.4 2.9e-05 0)
Vd_r0c4l d_r0c4l 0 pwl(
+ 0 0 4e-07 0 5e-07 0.05 2.91e-05 0.05 2.92e-05 0)
Xr0c4l g_r0c4l d_r0c4l 0 0 fefet_c16 x0_1=-1 x0_2=-1 x0_3=-1 x0_4=-1 x0_5=-1 x0_6=-1
+ x0_7=-1 x0_8=-1 x0_9=-1 x0_10=-1 x0_11=-1 x0_12=-1
+ x0_13=-1 x0_14=-1 x0_15=-1 x0_16=-1
.ic v(xr0c4l.m)=-0.277154442
Vg_r0c4r g_r0c4r 0 pwl(
+ 0 0 1e-06 0 2e-06 -0.2 2.2e-06 -0.18 2.4e-06 -0.16 2.6e-06 -0.14
+ 2.8e-06 -0.12 3e-06 -0.1 3.2e-06 -0.08 3.4e-06 -0.06 3.6e-06 -0.04 3.8e-06 -0.02
+ 4e-06 0 4.2e-06 0.02 4.4e-06 0.04 4.6e-06 0.06 4.8e-06 0.08 5e-06 0.1
+ 5.2e-06 0.12 5.4e-06 0.14 5.6e-06 0.16 5.8e-06 0.18 6e-06 0.2 6.2e-06 0.22
+ 6.4e-06 0.24 6.6e-06 0.26 6.8e-06 0.28 7e-06 0.3 7.2e-06 0.32 7.4e-06 0.34
+ 7.6e-06 0.36 7.8e-06 0.38 8e-06 0.4 8.2e-06 0.42 8.4e-06 0.44 8.6e-06 0.46
+ 8.8e-06 0.48 9e-06 0.5 9.2e-06 0.52 9.4e-06 0.54 9.6e-06 0.56 9.8e-06 0.58
+ 1e-05 0.6 1.02e-05 0.62 1.04e-05 0.64 1.06e-05 0.66 1.08e-05 0.68 1.1e-05 0.7
+ 1.12e-05 0.72 1.14e-05 0.74 1.16e-05 0.76 1.18e-05 0.78 1.2e-05 0.8 1.22e-05 0.82
+ 1.24e-05 0.84 1.26e-05 0.86 1.28e-05 0.88 1.3e-05 0.9 1.32e-05 0.92 1.34e-05 0.94
+ 1.36e-05 0.96 1.38e-05 0.98 1.4e-05 1 1.42e-05 1.02 1.44e-05 1.04 1.46e-05 1.06
+ 1.48e-05 1.08 1.5e-05 1.1 1.52e-05 1.12 1.54e-05 1.14 1.56e-05 1.16 1.58e-05 1.18
+ 1.6e-05 1.2 1.62e-05 1.22 1.64e-05 1.24 1.66e-05 1.26 1.68e-05 1.28 1.7e-05 1.3
+ 1.72e-05 1.32 1.74e-05 1.34 1.76e-05 1.36 1.78e-05 1.38 1.8e-05 1.4 1.82e-05 1.42
+ 1.84e-05 1.44 1.86e-05 1.46 1.88e-05 1.48 1.9e-05 1.5 1.92e-05 1.52 1.94e-05 1.54
+ 1.96e-05 1.56 1.98e-05 1.58 2e-05 1.6 2.02e-05 1.62 2.04e-05 1.64 2.06e-05 1.66
+ 2.08e-05 1.68 2.1e-05 1.7 2.12e-05 1.72 2.14e-05 1.74 2.16e-05 1.76 2.18e-05 1.78
+ 2.2e-05 1.8 2.22e-05 1.82 2.24e-05 1.84 2.26e-05 1.86 2.28e-05 1.88 2.3e-05 1.9
+ 2.32e-05 1.92 2.34e-05 1.94 2.36e-05 1.96 2.38e-05 1.98 2.4e-05 2 2.42e-05 2.02
+ 2.44e-05 2.04 2.46e-05 2.06 2.48e-05 2.08 2.5e-05 2.1 2.52e-05 2.12 2.54e-05 2.14
+ 2.56e-05 2.16 2.58e-05 2.18 2.6e-05 2.2 2.62e-05 2.22 2.64e-05 2.24 2.66e-05 2.26
+ 2.68e-05 2.28 2.7e-05 2.3 2.72e-05 2.32 2.74e-05 2.34 2.76e-05 2.36 2.78e-05 2.38
+ 2.8e-05 2.4 2.9e-05 0)
Vd_r0c4r d_r0c4r 0 pwl(
+ 0 0 4e-07 0 5e-07 0.05 2.91e-05 0.05 2.92e-05 0)
Xr0c4r g_r0c4r d_r0c4r 0 0 fefet_c16 x0_1=-1 x0_2=-1 x0_3=-1 x0_4=-1 x0_5=-1 x0_6=-1
+ x0_7=-1 x0_8=-1 x0_9=-1 x0_10=-1 x0_11=-1 x0_12=-1
+ x0_13=-1 x0_14=-1 x0_15=-1 x0_16=-1
.ic v(xr0c4r.m)=-0.277154442
Vg_r0c5l g_r0c5l 0 pwl(
+ 0 0 1e-06 0 2e-06 -0.2 2.2e-06 -0.18 2.4e-06 -0.16 2.6e-06 -0.14
+ 2.8e-06 -0.12 3e-06 -0.1 3.2e-06 -0.08 3.4e-06 -0.06 3.6e-06 -0.04 3.8e-06 -0.02
+ 4e-06 0 4.2e-06 0.02 4.4e-06 0.04 4.6e-06 0.06 4.8e-06 0.08 5e-06 0.1
+ 5.2e-06 0.12 5.4e-06 0.14 5.6e-06 0.16 5.8e-06 0.18 6e-06 0.2 6.2e-06 0.22
+ 6.4e-06 0.24 6.6e-06 0.26 6.8e-06 0.28 7e-06 0.3 7.2e-06 0.32 7.4e-06 0.34
+ 7.6e-06 0.36 7.8e-06 0.38 8e-06 0.4 8.2e-06 0.42 8.4e-06 0.44 8.6e-06 0.46
+ 8.8e-06 0.48 9e-06 0.5 9.2e-06 0.52 9.4e-06 0.54 9.6e-06 0.56 9.8e-06 0.58
+ 1e-05 0.6 1.02e-05 0.62 1.04e-05 0.64 1.06e-05 0.66 1.08e-05 0.68 1.1e-05 0.7
+ 1.12e-05 0.72 1.14e-05 0.74 1.16e-05 0.76 1.18e-05 0.78 1.2e-05 0.8 1.22e-05 0.82
+ 1.24e-05 0.84 1.26e-05 0.86 1.28e-05 0.88 1.3e-05 0.9 1.32e-05 0.92 1.34e-05 0.94
+ 1.36e-05 0.96 1.38e-05 0.98 1.4e-05 1 1.42e-05 1.02 1.44e-05 1.04 1.46e-05 1.06
+ 1.48e-05 1.08 1.5e-05 1.1 1.52e-05 1.12 1.54e-05 1.14 1.56e-05 1.16 1.58e-05 1.18
+ 1.6e-05 1.2 1.62e-05 1.22 1.64e-05 1.24 1.66e-05 1.26 1.68e-05 1.28 1.7e-05 1.3
+ 1.72e-05 1.32 1.74e-05 1.34 1.76e-05 1.36 1.78e-05 1.38 1.8e-05 1.4 1.82e-05 1.42
+ 1.84e-05 1.44 1.86e-05 1.46 1.88e-05 1.48 1.9e-05 1.5 1.92e-05 1.52 1.94e-05 1.54
+ 1.96e-05 1.56 1.98e-05 1.58 2e-05 1.6 2.02e-05 1.62 2.04e-05 1.64 2.06e-05 1.66
+ 2.08e-05 1.68 2.1e-05 1.7 2.12e-05 1.72 2.14e-05 1.74 2.16e-05 1.76 2.18e-05 1.78
+ 2.2e-05 1.8 2.22e-05 1.82 2.24e-05 1.84 2.26e-05 1.86 2.28e-05 1.88 2.3e-05 1.9
+ 2.32e-05 1.92 2.34e-05 1.94 2.36e-05 1.96 2.38e-05 1.98 2.4e-05 2 2.42e-05 2.02
+ 2.44e-05 2.04 2.46e-05 2.06 2.48e-05 2.08 2.5e-05 2.1 2.52e-05 2.12 2.54e-05 2.14
+ 2.56e-05 2.16 2.58e-05 2.18 2.6e-05 2.2 2.62e-05 2.22 2.64e-05 2.24 2.66e-05 2.26
+ 2.68e-05 2.28 2.7e-05 2.3 2.72e-05 2.32 2.74e-05 2.34 2.76e-05 2.36 2.78e-05 2.38
+ 2.8e-05 2.4 2.9e-05 0)
Vd_r0c5l d_r0c5l 0 pwl(
+ 0 0 4e-07 0 5e-07 0.05 2.91e-05 0.05 2.92e-05 0)
Xr0c5l g_r0c5l d_r0c5l 0 0 fefet_c16 x0_1=-1 x0_2=-1 x0_3=-1 x0_4=-1 x0_5=-1 x0_6=-1
+ x0_7=-1 x0_8=-1 x0_9=-1 x0_10=-1 x0_11=-1 x0_12=-1
+ x0_13=-1 x0_14=-1 x0_15=-1 x0_16=-1
.ic v(xr0c5l.m)=-0.277157633
Vg_r0c5r g_r0c5r 0 pwl(
+ 0 0 1e-06 0 2e-06 -0.2 2.2e-06 -0.18 2.4e-06 -0.16 2.6e-06 -0.14
+ 2.8e-06 -0.12 3e-06 -0.1 3.2e-06 -0.08 3.4e-06 -0.06 3.6e-06 -0.04 3.8e-06 -0.02
+ 4e-06 0 4.2e-06 0.02 4.4e-06 0.04 4.6e-06 0.06 4.8e-06 0.08 5e-06 0.1
+ 5.2e-06 0.12 5.4e-06 0.14 5.6e-06 0.16 5.8e-06 0.18 6e-06 0.2 6.2e-06 0.22
+ 6.4e-06 0.24 6.6e-06 0.26 6.8e-06 0.28 7e-06 0.3 7.2e-06 0.32 7.4e-06 0.34
+ 7.6e-06 0.36 7.8e-06 0.38 8e-06 0.4 8.2e-06 0.42 8.4e-06 0.44 8.6e-06 0.46
+ 8.8e-06 0.48 9e-06 0.5 9.2e-06 0.52 9.4e-06 0.54 9.6e-06 0.56 9.8e-06 0.58
+ 1e-05 0.6 1.02e-05 0.62 1.04e-05 0.64 1.06e-05 0.66 1.08e-05 0.68 1.1e-05 0.7
+ 1.12e-05 0.72 1.14e-05 0.74 1.16e-05 0.76 1.18e-05 0.78 1.2e-05 0.8 1.22e-05 0.82
+ 1.24e-05 0.84 1.26e-05 0.86 1.28e-05 0.88 1.3e-05 0.9 1.32e-05 0.92 1.34e-05 0.94
+ 1.36e-05 0.96 1.38e-05 0.98 1.4e-05 1 1.42e-05 1.02 1.44e-05 1.04 1.46e-05 1.06
+ 1.48e-05 1.08 1.5e-05 1.1 1.52e-05 1.12 1.54e-05 1.14 1.56e-05 1.16 1.58e-05 1.18
+ 1.6e-05 1.2 1.62e-05 1.22 1.64e-05 1.24 1.66e-05 1.26 1.68e-05 1.28 1.7e-05 1.3
+ 1.72e-05 1.32 1.74e-05 1.34 1.76e-05 1.36 1.78e-05 1.38 1.8e-05 1.4 1.82e-05 1.42
+ 1.84e-05 1.44 1.86e-05 1.46 1.88e-05 1.48 1.9e-05 1.5 1.92e-05 1.52 1.94e-05 1.54
+ 1.96e-05 1.56 1.98e-05 1.58 2e-05 1.6 2.02e-05 1.62 2.04e-05 1.64 2.06e-05 1.66
+ 2.08e-05 1.68 2.1e-05 1.7 2.12e-05 1.72 2.14e-05 1.74 2.16e-05 1.76 2.18e-05 1.78
+ 2.2e-05 1.8 2.22e-05 1.82 2.24e-05 1.84 2.26e-05 1.86 2.28e-05 1.88 2.3e-05 1.9
+ 2.32e-05 1.92 2.34e-05 1.94 2.36e-05 1.96 2.38e-05 1.98 2.4e-05 2 2.42e-05 2.02
+ 2.44e-05 2.04 2.46e-05 2.06 2.48e-05 2.08 2.5e-05 2.1 2.52e-05 2.12 2.54e-05 2.14
+ 2.56e-05 2.16 2.58e-05 2.18 2.6e-05 2.2 2.62e-05 2.22 2.64e-05 2.24 2.66e-05 2.26
+ 2.68e-05 2.28 2.7e-05 2.3 2.72e-05 2.32 2.74e-05 2.34 2.76e-05 2.36 2.78e-05 2.38
+ 2.8e-05 2.4 2.9e-05 0)
Vd_r0c5r d_r0c5r 0 pwl(
+ 0 0 4e-07 0 5e-07 0.05 2.91e-05 0.05 2.92e-05 0)
Xr0c5r g_r0c5r d_r0c5r 0 0 fefet_c16 x0_1=0.999999999 x0_2=0.999999981 x0_3=0.999999958 x0_4=0.999999968 x0_5=1.00000008 x0_6=1.00000039
+ x0_7=1.00000101 x0_8=1.00000201 x0_9=1.00000329 x0_10=1.00000414 x0_11=1.00000239 x0_12=0.999992197
+ x0_13=0.999959838 x0_14=0.99988151 x0_15=0.999818708 x0_16=1.00239255
.ic v(xr0c5r.m)=0.424867794
Vg_r0c6l g_r0c6l 0 pwl(
+ 0 0 1e-06 0 2e-06 -0.2 2.2e-06 -0.18 2.4e-06 -0.16 2.6e-06 -0.14
+ 2.8e-06 -0.12 3e-06 -0.1 3.2e-06 -0.08 3.4e-06 -0.06 3.6e-06 -0.04 3.8e-06 -0.02
+ 4e-06 0 4.2e-06 0.02 4.4e-06 0.04 4.6e-06 0.06 4.8e-06 0.08 5e-06 0.1
+ 5.2e-06 0.12 5.4e-06 0.14 5.6e-06 0.16 5.8e-06 0.18 6e-06 0.2 6.2e-06 0.22
+ 6.4e-06 0.24 6.6e-06 0.26 6.8e-06 0.28 7e-06 0.3 7.2e-06 0.32 7.4e-06 0.34
+ 7.6e-06 0.36 7.8e-06 0.38 8e-06 0.4 8.2e-06 0.42 8.4e-06 0.44 8.6e-06 0.46
+ 8.8e-06 0.48 9e-06 0.5 9.2e-06 0.52 9.4e-06 0.54 9.6e-06 0.56 9.8e-06 0.58
+ 1e-05 0.6 1.02e-05 0.62 1.04e-05 0.64 1.06e-05 0.66 1.08e-05 0.68 1.1e-05 0.7
+ 1.12e-05 0.72 1.14e-05 0.74 1.16e-05 0.76 1.18e-05 0.78 1.2e-05 0.8 1.22e-05 0.82
+ 1.24e-05 0.84 1.26e-05 0.86 1.28e-05 0.88 1.3e-05 0.9 1.32e-05 0.92 1.34e-05 0.94
+ 1.36e-05 0.96 1.38e-05 0.98 1.4e-05 1 1.42e-05 1.02 1.44e-05 1.04 1.46e-05 1.06
+ 1.48e-05 1.08 1.5e-05 1.1 1.52e-05 1.12 1.54e-05 1.14 1.56e-05 1.16 1.58e-05 1.18
+ 1.6e-05 1.2 1.62e-05 1.22 1.64e-05 1.24 1.66e-05 1.26 1.68e-05 1.28 1.7e-05 1.3
+ 1.72e-05 1.32 1.74e-05 1.34 1.76e-05 1.36 1.78e-05 1.38 1.8e-05 1.4 1.82e-05 1.42
+ 1.84e-05 1.44 1.86e-05 1.46 1.88e-05 1.48 1.9e-05 1.5 1.92e-05 1.52 1.94e-05 1.54
+ 1.96e-05 1.56 1.98e-05 1.58 2e-05 1.6 2.02e-05 1.62 2.04e-05 1.64 2.06e-05 1.66
+ 2.08e-05 1.68 2.1e-05 1.7 2.12e-05 1.72 2.14e-05 1.74 2.16e-05 1.76 2.18e-05 1.78
+ 2.2e-05 1.8 2.22e-05 1.82 2.24e-05 1.84 2.26e-05 1.86 2.28e-05 1.88 2.3e-05 1.9
+ 2.32e-05 1.92 2.34e-05 1.94 2.36e-05 1.96 2.38e-05 1.98 2.4e-05 2 2.42e-05 2.02
+ 2.44e-05 2.04 2.46e-05 2.06 2.48e-05 2.08 2.5e-05 2.1 2.52e-05 2.12 2.54e-05 2.14
+ 2.56e-05 2.16 2.58e-05 2.18 2.6e-05 2.2 2.62e-05 2.22 2.64e-05 2.24 2.66e-05 2.26
+ 2.68e-05 2.28 2.7e-05 2.3 2.72e-05 2.32 2.74e-05 2.34 2.76e-05 2.36 2.78e-05 2.38
+ 2.8e-05 2.4 2.9e-05 0)
Vd_r0c6l d_r0c6l 0 pwl(
+ 0 0 4e-07 0 5e-07 0.05 2.91e-05 0.05 2.92e-05 0)
Xr0c6l g_r0c6l d_r0c6l 0 0 fefet_c16 x0_1=0.999999999 x0_2=0.999999981 x0_3=0.999999958 x0_4=0.999999968 x0_5=1.00000008 x0_6=1.00000039
+ x0_7=1.00000101 x0_8=1.00000201 x0_9=1.00000329 x0_10=1.00000414 x0_11=1.00000239 x0_12=0.999992197
+ x0_13=0.999959838 x0_14=0.99988151 x0_15=0.999818708 x0_16=1.00239255
.ic v(xr0c6l.m)=0.424867794
Vg_r0c6r g_r0c6r 0 pwl(
+ 0 0 1e-06 0 2e-06 -0.2 2.2e-06 -0.18 2.4e-06 -0.16 2.6e-06 -0.14
+ 2.8e-06 -0.12 3e-06 -0.1 3.2e-06 -0.08 3.4e-06 -0.06 3.6e-06 -0.04 3.8e-06 -0.02
+ 4e-06 0 4.2e-06 0.02 4.4e-06 0.04 4.6e-06 0.06 4.8e-06 0.08 5e-06 0.1
+ 5.2e-06 0.12 5.4e-06 0.14 5.6e-06 0.16 5.8e-06 0.18 6e-06 0.2 6.2e-06 0.22
+ 6.4e-06 0.24 6.6e-06 0.26 6.8e-06 0.28 7e-06 0.3 7.2e-06 0.32 7.4e-06 0.34
+ 7.6e-06 0.36 7.8e-06 0.38 8e-06 0.4 8.2e-06 0.42 8.4e-06 0.44 8.6e-06 0.46
+ 8.8e-06 0.48 9e-06 0.5 9.2e-06 0.52 9.4e-06 0.54 9.6e-06 0.56 9.8e-06 0.58
+ 1e-05 0.6 1.02e-05 0.62 1.04e-05 0.64 1.06e-05 0.66 1.08e-05 0.68 1.1e-05 0.7
+ 1.12e-05 0.72 1.14e-05 0.74 1.16e-05 0.76 1.18e-05 0.78 1.2e-05 0.8 1.22e-05 0.82
+ 1.24e-05 0.84 1.26e-05 0.86 1.28e-05 0.88 1.3e-05 0.9 1.32e-05 0.92 1.34e-05 0.94
+ 1.36e-05 0.96 1.38e-05 0.98 1.4e-05 1 1.42e-05 1.02 1.44e-05 1.04 1.46e-05 1.06
+ 1.48e-05 1.08 1.5e-05 1.1 1.52e-05 1.12 1.54e-05 1.14 1.56e-05 1.16 1.58e-05 1.18
+ 1.6e-05 1.2 1.62e-05 1.22 1.64e-05 1.24 1.66e-05 1.26 1.68e-05 1.28 1.7e-05 1.3
+ 1.72e-05 1.32 1.74e-05 1.34 1.76e-05 1.36 1.78e-05 1.38 1.8e-05 1.4 1.82e-05 1.42
+ 1.84e-05 1.44 1.86e-05 1.46 1.88e-05 1.48 1.9e-05 1.5 1.92e-05 1.52 1.94e-05 1.54
+ 1.96e-05 1.56 1.98e-05 1.58 2e-05 1.6 2.02e-05 1.62 2.04e-05 1.64 2.06e-05 1.66
+ 2.08e-05 1.68 2.1e-05 1.7 2.12e-05 1.72 2.14e-05 1.74 2.16e-05 1.76 2.18e-05 1.78
+ 2.2e-05 1.8 2.22e-05 1.82 2.24e-05 1.84 2.26e-05 1.86 2.28e-05 1.88 2.3e-05 1.9
+ 2.32e-05 1.92 2.34e-05 1.94 2.36e-05 1.96 2.38e-05 1.98 2.4e-05 2 2.42e-05 2.02
+ 2.44e-05 2.04 2.46e-05 2.06 2.48e-05 2.08 2.5e-05 2.1 2.52e-05 2.12 2.54e-05 2.14
+ 2.56e-05 2.16 2.58e-05 2.18 2.6e-05 2.2 2.62e-05 2.22 2.64e-05 2.24 2.66e-05 2.26
+ 2.68e-05 2.28 2.7e-05 2.3 2.72e-05 2.32 2.74e-05 2.34 2.76e-05 2.36 2.78e-05 2.38
+ 2.8e-05 2.4 2.9e-05 0)
Vd_r0c6r d_r0c6r 0 pwl(
+ 0 0 4e-07 0 5e-07 0.05 2.91e-05 0.05 2.92e-05 0)
Xr0c6r g_r0c6r d_r0c6r 0 0 fefet_c16 x0_1=-1 x0_2=-1 x0_3=-1 x0_4=-1 x0_5=-1 x0_6=-1
+ x0_7=-1 x0_8=-1 x0_9=-1 x0_10=-1 x0_11=-1 x0_12=-1
+ x0_13=-1 x0_14=-1 x0_15=-1 x0_16=-1
.ic v(xr0c6r.m)=-0.277157633
Vg_r0c7l g_r0c7l 0 pwl(
+ 0 0 1e-06 0 2e-06 -0.2 2.2e-06 -0.18 2.4e-06 -0.16 2.6e-06 -0.14
+ 2.8e-06 -0.12 3e-06 -0.1 3.2e-06 -0.08 3.4e-06 -0.06 3.6e-06 -0.04 3.8e-06 -0.02
+ 4e-06 0 4.2e-06 0.02 4.4e-06 0.04 4.6e-06 0.06 4.8e-06 0.08 5e-06 0.1
+ 5.2e-06 0.12 5.4e-06 0.14 5.6e-06 0.16 5.8e-06 0.18 6e-06 0.2 6.2e-06 0.22
+ 6.4e-06 0.24 6.6e-06 0.26 6.8e-06 0.28 7e-06 0.3 7.2e-06 0.32 7.4e-06 0.34
+ 7.6e-06 0.36 7.8e-06 0.38 8e-06 0.4 8.2e-06 0.42 8.4e-06 0.44 8.6e-06 0.46
+ 8.8e-06 0.48 9e-06 0.5 9.2e-06 0.52 9.4e-06 0.54 9.6e-06 0.56 9.8e-06 0.58
+ 1e-05 0.6 1.02e-05 0.62 1.04e-05 0.64 1.06e-05 0.66 1.08e-05 0.68 1.1e-05 0.7
+ 1.12e-05 0.72 1.14e-05 0.74 1.16e-05 0.76 1.18e-05 0.78 1.2e-05 0.8 1.22e-05 0.82
+ 1.24e-05 0.84 1.26e-05 0.86 1.28e-05 0.88 1.3e-05 0.9 1.32e-05 0.92 1.34e-05 0.94
+ 1.36e-05 0.96 1.38e-05 0.98 1.4e-05 1 1.42e-05 1.02 1.44e-05 1.04 1.46e-05 1.06
+ 1.48e-05 1.08 1.5e-05 1.1 1.52e-05 1.12 1.54e-05 1.14 1.56e-05 1.16 1.58e-05 1.18
+ 1.6e-05 1.2 1.62e-05 1.22 1.64e-05 1.24 1.66e-05 1.26 1.68e-05 1.28 1.7e-05 1.3
+ 1.72e-05 1.32 1.74e-05 1.34 1.76e-05 1.36 1.78e-05 1.38 1.8e-05 1.4 1.82e-05 1.42
+ 1.84e-05 1.44 1.86e-05 1.46 1.88e-05 1.48 1.9e-05 1.5 1.92e-05 1.52 1.94e-05 1.54
+ 1.96e-05 1.56 1.98e-05 1.58 2e-05 1.6 2.02e-05 1.62 2.04e-05 1.64 2.06e-05 1.66
+ 2.08e-05 1.68 2.1e-05 1.7 2.12e-05 1.72 2.14e-05 1.74 2.16e-05 1.76 2.18e-05 1.78
+ 2.2e-05 1.8 2.22e-05 1.82 2.24e-05 1.84 2.26e-05 1.86 2.28e-05 1.88 2.3e-05 1.9
+ 2.32e-05 1.92 2.34e-05 1.94 2.36e-05 1.96 2.38e-05 1.98 2.4e-05 2 2.42e-05 2.02
+ 2.44e-05 2.04 2.46e-05 2.06 2.48e-05 2.08 2.5e-05 2.1 2.52e-05 2.12 2.54e-05 2.14
+ 2.56e-05 2.16 2.58e-05 2.18 2.6e-05 2.2 2.62e-05 2.22 2.64e-05 2.24 2.66e-05 2.26
+ 2.68e-05 2.28 2.7e-05 2.3 2.72e-05 2.32 2.74e-05 2.34 2.76e-05 2.36 2.78e-05 2.38
+ 2.8e-05 2.4 2.9e-05 0)
Vd_r0c7l d_r0c7l 0 pwl(
+ 0 0 4e-07 0 5e-07 0.05 2.91e-05 0.05 2.92e-05 0)
Xr0c7l g_r0c7l d_r0c7l 0 0 fefet_c16 x0_1=0.999999999 x0_2=0.999999981 x0_3=0.999999958 x0_4=0.999999968 x0_5=1.00000008 x0_6=1.00000039
+ x0_7=1.00000101 x0_8=1.00000201 x0_9=1.00000329 x0_10=1.00000414 x0_11=1.00000239 x0_12=0.999992197
+ x0_13=0.999959838 x0_14=0.99988151 x0_15=0.999818708 x0_16=1.00239255
.ic v(xr0c7l.m)=0.424867794
Vg_r0c7r g_r0c7r 0 pwl(
+ 0 0 1e-06 0 2e-06 -0.2 2.2e-06 -0.18 2.4e-06 -0.16 2.6e-06 -0.14
+ 2.8e-06 -0.12 3e-06 -0.1 3.2e-06 -0.08 3.4e-06 -0.06 3.6e-06 -0.04 3.8e-06 -0.02
+ 4e-06 0 4.2e-06 0.02 4.4e-06 0.04 4.6e-06 0.06 4.8e-06 0.08 5e-06 0.1
+ 5.2e-06 0.12 5.4e-06 0.14 5.6e-06 0.16 5.8e-06 0.18 6e-06 0.2 6.2e-06 0.22
+ 6.4e-06 0.24 6.6e-06 0.26 6.8e-06 0.28 7e-06 0.3 7.2e-06 0.32 7.4e-06 0.34
+ 7.6e-06 0.36 7.8e-06 0.38 8e-06 0.4 8.2e-06 0.42 8.4e-06 0.44 8.6e-06 0.46
+ 8.8e-06 0.48 9e-06 0.5 9.2e-06 0.52 9.4e-06 0.54 9.6e-06 0.56 9.8e-06 0.58
+ 1e-05 0.6 1.02e-05 0.62 1.04e-05 0.64 1.06e-05 0.66 1.08e-05 0.68 1.1e-05 0.7
+ 1.12e-05 0.72 1.14e-05 0.74 1.16e-05 0.76 1.18e-05 0.78 1.2e-05 0.8 1.22e-05 0.82
+ 1.24e-05 0.84 1.26e-05 0.86 1.28e-05 0.88 1.3e-05 0.9 1.32e-05 0.92 1.34e-05 0.94
+ 1.36e-05 0.96 1.38e-05 0.98 1.4e-05 1 1.42e-05 1.02 1.44e-05 1.04 1.46e-05 1.06
+ 1.48e-05 1.08 1.5e-05 1.1 1.52e-05 1.12 1.54e-05 1.14 1.56e-05 1.16 1.58e-05 1.18
+ 1.6e-05 1.2 1.62e-05 1.22 1.64e-05 1.24 1.66e-05 1.26 1.68e-05 1.28 1.7e-05 1.3
+ 1.72e-05 1.32 1.74e-05 1.34 1.76e-05 1.36 1.78e-05 1.38 1.8e-05 1.4 1.82e-05 1.42
+ 1.84e-05 1.44 1.86e-05 1.46 1.88e-05 1.48 1.9e-05 1.5 1.92e-05 1.52 1.94e-05 1.54
+ 1.96e-05 1.56 1.98e-05 1.58 2e-05 1.6 2.02e-05 1.62 2.04e-05 1.64 2.06e-05 1.66
+ 2.08e-05 1.68 2.1e-05 1.7 2.12e-05 1.72 2.14e-05 1.74 2.16e-05 1.76 2.18e-05 1.78
+ 2.2e-05 1.8 2.22e-05 1.82 2.24e-05 1.84 2.26e-05 1.86 2.28e-05 1.88 2.3e-05 1.9
+ 2.32e-05 1.92 2.34e-05 1.94 2.36e-05 1.96 2.38e-05 1.98 2.4e-05 2 2.42e-05 2.02
+ 2.44e-05 2.04 2.46e-05 2.06 2.48e-05 2.08 2.5e-05 2.1 2.52e-05 2.12 2.54e-05 2.14
+ 2.56e-05 2.16 2.58e-05 2.18 2.6e-05 2.2 2.62e-05 2.22 2.64e-05 2.24 2.66e-05 2.26
+ 2.68e-05 2.28 2.7e-05 2.3 2.72e-05 2.32 2.74e-05 2.34 2.76e-05 2.36 2.78e-05 2.38
+ 2.8e-05 2.4 2.9e-05 0)
Vd_r0c7r d_r0c7r 0 pwl(
+ 0 0 4e-07 0 5e-07 0.05 2.91e-05 0.05 2.92e-05 0)
Xr0c7r g_r0c7r d_r0c7r 0 0 fefet_c16 x0_1=-1 x0_2=-1 x0_3=-1 x0_4=-1 x0_5=-1 x0_6=-1
+ x0_7=-1 x0_8=-1 x0_9=-1 x0_10=-1 x0_11=-1 x0_12=-1
+ x0_13=-1 x0_14=-1 x0_15=-1 x0_16=-1
.ic v(xr0c7r.m)=-0.277157633
Vg_r1c0l g_r1c0l 0 pwl(
+ 0 0 1e-06 0 2e-06 -0.2 2.2e-06 -0.18 2.4e-06 -0.16 2.6e-06 -0.14
+ 2.8e-06 -0.12 3e-06 -0.1 3.2e-06 -0.08 3.4e-06 -0.06 3.6e-06 -0.04 3.8e-06 -0.02
+ 4e-06 0 4.2e-06 0.02 4.4e-06 0.04 4.6e-06 0.06 4.8e-06 0.08 5e-06 0.1
+ 5.2e-06 0.12 5.4e-06 0.14 5.6e-06 0.16 5.8e-06 0.18 6e-06 0.2 6.2e-06 0.22
+ 6.4e-06 0.24 6.6e-06 0.26 6.8e-06 0.28 7e-06 0.3 7.2e-06 0.32 7.4e-06 0.34
+ 7.6e-06 0.36 7.8e-06 0.38 8e-06 0.4 8.2e-06 0.42 8.4e-06 0.44 8.6e-06 0.46
+ 8.8e-06 0.48 9e-06 0.5 9.2e-06 0.52 9.4e-06 0.54 9.6e-06 0.56 9.8e-06 0.58
+ 1e-05 0.6 1.02e-05 0.62 1.04e-05 0.64 1.06e-05 0.66 1.08e-05 0.68 1.1e-05 0.7
+ 1.12e-05 0.72 1.14e-05 0.74 1.16e-05 0.76 1.18e-05 0.78 1.2e-05 0.8 1.22e-05 0.82
+ 1.24e-05 0.84 1.26e-05 0.86 1.28e-05 0.88 1.3e-05 0.9 1.32e-05 0.92 1.34e-05 0.94
+ 1.36e-05 0.96 1.38e-05 0.98 1.4e-05 1 1.42e-05 1.02 1.44e-05 1.04 1.46e-05 1.06
+ 1.48e-05 1.08 1.5e-05 1.1 1.52e-05 1.12 1.54e-05 1.14 1.56e-05 1.16 1.58e-05 1.18
+ 1.6e-05 1.2 1.62e-05 1.22 1.64e-05 1.24 1.66e-05 1.26 1.68e-05 1.28 1.7e-05 1.3
+ 1.72e-05 1.32 1.74e-05 1.34 1.76e-05 1.36 1.78e-05 1.38 1.8e-05 1.4 1.82e-05 1.42
+ 1.84e-05 1.44 1.86e-05 1.46 1.88e-05 1.48 1.9e-05 1.5 1.92e-05 1.52 1.94e-05 1.54
+ 1.96e-05 1.56 1.98e-05 1.58 2e-05 1.6 2.02e-05 1.62 2.04e-05 1.64 2.06e-05 1.66
+ 2.08e-05 1.68 2.1e-05 1.7 2.12e-05 1.72 2.14e-05 1.74 2.16e-05 1.76 2.18e-05 1.78
+ 2.2e-05 1.8 2.22e-05 1.82 2.24e-05 1.84 2.26e-05 1.86 2.28e-05 1.88 2.3e-05 1.9
+ 2.32e-05 1.92 2.34e-05 1.94 2.36e-05 1.96 2.38e-05 1.98 2.4e-05 2 2.42e-05 2.02
+ 2.44e-05 2.04 2.46e-05 2.06 2.48e-05 2.08 2.5e-05 2.1 2.52e-05 2.12 2.54e-05 2.14
+ 2.56e-05 2.16 2.58e-05 2.18 2.6e-05 2.2 2.62e-05 2.22 2.64e-05 2.24 2.66e-05 2.26
+ 2.68e-05 2.28 2.7e-05 2.3 2.72e-05 2.32 2.74e-05 2.34 2.76e-05 2.36 2.78e-05 2.38
+ 2.8e-05 2.4 2.9e-05 0)
Vd_r1c0l d_r1c0l 0 pwl(
+ 0 0 4e-07 0 5e-07 0.05 2.91e-05 0.05 2.92e-05 0)
Xr1c0l g_r1c0l d_r1c0l 0 0 fefet_c16 x0_1=-0.999276974 x0_2=-0.963360144 x0_3=-0.867091747 x0_4=-0.730133867 x0_5=-0.571807384 x0_6=-0.40492262
+ x0_7=-0.237640667 x0_8=-0.074609272 x0_9=0.0811871949 x0_10=0.228444308 x0_11=0.36635266 x0_12=0.494806973
+ x0_13=0.61409885 x0_14=0.724945713 x0_15=0.828795173 x0_16=0.930424416
.ic v(xr1c0l.m)=-0.0138685264
Vg_r1c0r g_r1c0r 0 pwl(
+ 0 0 1e-06 0 2e-06 -0.2 2.2e-06 -0.18 2.4e-06 -0.16 2.6e-06 -0.14
+ 2.8e-06 -0.12 3e-06 -0.1 3.2e-06 -0.08 3.4e-06 -0.06 3.6e-06 -0.04 3.8e-06 -0.02
+ 4e-06 0 4.2e-06 0.02 4.4e-06 0.04 4.6e-06 0.06 4.8e-06 0.08 5e-06 0.1
+ 5.2e-06 0.12 5.4e-06 0.14 5.6e-06 0.16 5.8e-06 0.18 6e-06 0.2 6.2e-06 0.22
+ 6.4e-06 0.24 6.6e-06 0.26 6.8e-06 0.28 7e-06 0.3 7.2e-06 0.32 7.4e-06 0.34
+ 7.6e-06 0.36 7.8e-06 0.38 8e-06 0.4 8.2e-06 0.42 8.4e-06 0.44 8.6e-06 0.46
+ 8.8e-06 0.48 9e-06 0.5 9.2e-06 0.52 9.4e-06 0.54 9.6e-06 0.56 9.8e-06 0.58
+ 1e-05 0.6 1.02e-05 0.62 1.04e-05 0.64 1.06e-05 0.66 1.08e-05 0.68 1.1e-05 0.7
+ 1.12e-05 0.72 1.14e-05 0.74 1.16e-05 0.76 1.18e-05 0.78 1.2e-05 0.8 1.22e-05 0.82
+ 1.24e-05 0.84 1.26e-05 0.86 1.28e-05 0.88 1.3e-05 0.9 1.32e-05 0.92 1.34e-05 0.94
+ 1.36e-05 0.96 1.38e-05 0.98 1.4e-05 1 1.42e-05 1.02 1.44e-05 1.04 1.46e-05 1.06
+ 1.48e-05 1.08 1.5e-05 1.1 1.52e-05 1.12 1.54e-05 1.14 1.56e-05 1.16 1.58e-05 1.18
+ 1.6e-05 1.2 1.62e-05 1.22 1.64e-05 1.24 1.66e-05 1.26 1.68e-05 1.28 1.7e-05 1.3
+ 1.72e-05 1.32 1.74e-05 1.34 1.76e-05 1.36 1.78e-05 1.38 1.8e-05 1.4 1.82e-05 1.42
+ 1.84e-05 1.44 1.86e-05 1.46 1.88e-05 1.48 1.9e-05 1.5 1.92e-05 1.52 1.94e-05 1.54
+ 1.96e-05 1.56 1.98e-05 1.58 2e-05 1.6 2.02e-05 1.62 2.04e-05 1.64 2.06e-05 1.66
+ 2.08e-05 1.68 2.1e-05 1.7 2.12e-05 1.72 2.14e-05 1.74 2.16e-05 1.76 2.18e-05 1.78
+ 2.2e-05 1.8 2.22e-05 1.82 2.24e-05 1.84 2.26e-05 1.86 2.28e-05 1.88 2.3e-05 1.9
+ 2.32e-05 1.92 2.34e-05 1.94 2.36e-05 1.96 2.38e-05 1.98 2.4e-05 2 2.42e-05 2.02
+ 2.44e-05 2.04 2.46e-05 2.06 2.48e-05 2.08 2.5e-05 2.1 2.52e-05 2.12 2.54e-05 2.14
+ 2.56e-05 2.16 2.58e-05 2.18 2.6e-05 2.2 2.62e-05 2.22 2.64e-05 2.24 2.66e-05 2.26
+ 2.68e-05 2.28 2.7e-05 2.3 2.72e-05 2.32 2.74e-05 2.34 2.76e-05 2.36 2.78e-05 2.38
+ 2.8e-05 2.4 2.9e-05 0)
Vd_r1c0r d_r1c0r 0 pwl(
+ 0 0 4e-07 0 5e-07 0.05 2.91e-05 0.05 2.92e-05 0)
Xr1c0r g_r1c0r d_r1c0r 0 0 fefet_c16 x0_1=-0.998768253 x0_2=-0.999758157 x0_3=-0.999910837 x0_4=-0.999959796 x0_5=-0.99998005 x0_6=-0.999989598
+ x0_7=-0.999994445 x0_8=-0.99999702 x0_9=-0.999998418 x0_10=-0.999999183 x0_11=-0.999999598 x0_12=-0.999999816
+ x0_13=-0.999999926 x0_14=-0.999999976 x0_15=-0.999999995 x0_16=-1
.ic v(xr1c0r.m)=-0.277128463
Vg_r1c1l g_r1c1l 0 pwl(
+ 0 0 1e-06 0 2e-06 -0.2 2.2e-06 -0.18 2.4e-06 -0.16 2.6e-06 -0.14
+ 2.8e-06 -0.12 3e-06 -0.1 3.2e-06 -0.08 3.4e-06 -0.06 3.6e-06 -0.04 3.8e-06 -0.02
+ 4e-06 0 4.2e-06 0.02 4.4e-06 0.04 4.6e-06 0.06 4.8e-06 0.08 5e-06 0.1
+ 5.2e-06 0.12 5.4e-06 0.14 5.6e-06 0.16 5.8e-06 0.18 6e-06 0.2 6.2e-06 0.22
+ 6.4e-06 0.24 6.6e-06 0.26 6.8e-06 0.28 7e-06 0.3 7.2e-06 0.32 7.4e-06 0.34
+ 7.6e-06 0.36 7.8e-06 0.38 8e-06 0.4 8.2e-06 0.42 8.4e-06 0.44 8.6e-06 0.46
+ 8.8e-06 0.48 9e-06 0.5 9.2e-06 0.52 9.4e-06 0.54 9.6e-06 0.56 9.8e-06 0.58
+ 1e-05 0.6 1.02e-05 0.62 1.04e-05 0.64 1.06e-05 0.66 1.08e-05 0.68 1.1e-05 0.7
+ 1.12e-05 0.72 1.14e-05 0.74 1.16e-05 0.76 1.18e-05 0.78 1.2e-05 0.8 1.22e-05 0.82
+ 1.24e-05 0.84 1.26e-05 0.86 1.28e-05 0.88 1.3e-05 0.9 1.32e-05 0.92 1.34e-05 0.94
+ 1.36e-05 0.96 1.38e-05 0.98 1.4e-05 1 1.42e-05 1.02 1.44e-05 1.04 1.46e-05 1.06
+ 1.48e-05 1.08 1.5e-05 1.1 1.52e-05 1.12 1.54e-05 1.14 1.56e-05 1.16 1.58e-05 1.18
+ 1.6e-05 1.2 1.62e-05 1.22 1.64e-05 1.24 1.66e-05 1.26 1.68e-05 1.28 1.7e-05 1.3
+ 1.72e-05 1.32 1.74e-05 1.34 1.76e-05 1.36 1.78e-05 1.38 1.8e-05 1.4 1.82e-05 1.42
+ 1.84e-05 1.44 1.86e-05 1.46 1.88e-05 1.48 1.9e-05 1.5 1.92e-05 1.52 1.94e-05 1.54
+ 1.96e-05 1.56 1.98e-05 1.58 2e-05 1.6 2.02e-05 1.62 2.04e-05 1.64 2.06e-05 1.66
+ 2.08e-05 1.68 2.1e-05 1.7 2.12e-05 1.72 2.14e-05 1.74 2.16e-05 1.76 2.18e-05 1.78
+ 2.2e-05 1.8 2.22e-05 1.82 2.24e-05 1.84 2.26e-05 1.86 2.28e-05 1.88 2.3e-05 1.9
+ 2.32e-05 1.92 2.34e-05 1.94 2.36e-05 1.96 2.38e-05 1.98 2.4e-05 2 2.42e-05 2.02
+ 2.44e-05 2.04 2.46e-05 2.06 2.48e-05 2.08 2.5e-05 2.1 2.52e-05 2.12 2.54e-05 2.14
+ 2.56e-05 2.16 2.58e-05 2.18 2.6e-05 2.2 2.62e-05 2.22 2.64e-05 2.24 2.66e-05 2.26
+ 2.68e-05 2.28 2.7e-05 2.3 2.72e-05 2.32 2.74e-05 2.34 2.76e-05 2.36 2.78e-05 2.38
+ 2.8e-05 2.4 2.9e-05 0)
Vd_r1c1l d_r1c1l 0 pwl(
+ 0 0 4e-07 0 5e-07 0.05 2.91e-05 0.05 2.92e-05 0)
Xr1c1l g_r1c1l d_r1c1l 0 0 fefet_c16 x0_1=-0.998768253 x0_2=-0.999758157 x0_3=-0.999910837 x0_4=-0.999959796 x0_5=-0.99998005 x0_6=-0.999989598
+ x0_7=-0.999994445 x0_8=-0.99999702 x0_9=-0.999998418 x0_10=-0.999999183 x0_11=-0.999999598 x0_12=-0.999999816
+ x0_13=-0.999999926 x0_14=-0.999999976 x0_15=-0.999999995 x0_16=-1
.ic v(xr1c1l.m)=-0.277128463
Vg_r1c1r g_r1c1r 0 pwl(
+ 0 0 1e-06 0 2e-06 -0.2 2.2e-06 -0.18 2.4e-06 -0.16 2.6e-06 -0.14
+ 2.8e-06 -0.12 3e-06 -0.1 3.2e-06 -0.08 3.4e-06 -0.06 3.6e-06 -0.04 3.8e-06 -0.02
+ 4e-06 0 4.2e-06 0.02 4.4e-06 0.04 4.6e-06 0.06 4.8e-06 0.08 5e-06 0.1
+ 5.2e-06 0.12 5.4e-06 0.14 5.6e-06 0.16 5.8e-06 0.18 6e-06 0.2 6.2e-06 0.22
+ 6.4e-06 0.24 6.6e-06 0.26 6.8e-06 0.28 7e-06 0.3 7.2e-06 0.32 7.4e-06 0.34
+ 7.6e-06 0.36 7.8e-06 0.38 8e-06 0.4 8.2e-06 0.42 8.4e-06 0.44 8.6e-06 0.46
+ 8.8e-06 0.48 9e-06 0.5 9.2e-06 0.52 9.4e-06 0.54 9.6e-06 0.56 9.8e-06 0.58
+ 1e-05 0.6 1.02e-05 0.62 1.04e-05 0.64 1.06e-05 0.66 1.08e-05 0.68 1.1e-05 0.7
+ 1.12e-05 0.72 1.14e-05 0.74 1.16e-05 0.76 1.18e-05 0.78 1.2e-05 0.8 1.22e-05 0.82
+ 1.24e-05 0.84 1.26e-05 0.86 1.28e-05 0.88 1.3e-05 0.9 1.32e-05 0.92 1.34e-05 0.94
+ 1.36e-05 0.96 1.38e-05 0.98 1.4e-05 1 1.42e-05 1.02 1.44e-05 1.04 1.46e-05 1.06
+ 1.48e-05 1.08 1.5e-05 1.1 1.52e-05 1.12 1.54e-05 1.14 1.56e-05 1.16 1.58e-05 1.18
+ 1.6e-05 1.2 1.62e-05 1.22 1.64e-05 1.24 1.66e-05 1.26 1.68e-05 1.28 1.7e-05 1.3
+ 1.72e-05 1.32 1.74e-05 1.34 1.76e-05 1.36 1.78e-05 1.38 1.8e-05 1.4 1.82e-05 1.42
+ 1.84e-05 1.44 1.86e-05 1.46 1.88e-05 1.48 1.9e-05 1.5 1.92e-05 1.52 1.94e-05 1.54
+ 1.96e-05 1.56 1.98e-05 1.58 2e-05 1.6 2.02e-05 1.62 2.04e-05 1.64 2.06e-05 1.66
+ 2.08e-05 1.68 2.1e-05 1.7 2.12e-05 1.72 2.14e-05 1.74 2.16e-05 1.76 2.18e-05 1.78
+ 2.2e-05 1.8 2.22e-05 1.82 2.24e-05 1.84 2.26e-05 1.86 2.28e-05 1.88 2.3e-05 1.9
+ 2.32e-05 1.92 2.34e-05 1.94 2.36e-05 1.96 2.38e-05 1.98 2.4e-05 2 2.42e-05 2.02
+ 2.44e-05 2.04 2.46e-05 2.06 2.48e-05 2.08 2.5e-05 2.1 2.52e-05 2.12 2.54e-05 2.14
+ 2.56e-05 2.16 2.58e-05 2.18 2.6e-05 2.2 2.62e-05 2.22 2.64e-05 2.24 2.66e-05 2.26
+ 2.68e-05 2.28 2.7e-05 2.3 2.72e-05 2.32 2.74e-05 2.34 2.76e-05 2.36 2.78e-05 2.38
+ 2.8e-05 2.4 2.9e-05 0)
Vd_r1c1r d_r1c1r 0 pwl(
+ 0 0 4e-07 0 5e-07 0.05 2.91e-05 0.05 2.92e-05 0)
Xr1c1r g_r1c1r d_r1c1r 0 0 fefet_c16 x0_1=-0.999276974 x0_2=-0.963360144 x0_3=-0.867091747 x0_4=-0.730133867 x0_5=-0.571807384 x0_6=-0.40492262
+ x0_7=-0.237640667 x0_8=-0.074609272 x0_9=0.0811871949 x0_10=0.228444308 x0_11=0.36635266 x0_12=0.494806973
+ x0_13=0.61409885 x0_14=0.724945713 x0_15=0.828795173 x0_16=0.930424416
.ic v(xr1c1r.m)=-0.0138685264
Vg_r1c2l g_r1c2l 0 pwl(
+ 0 0 1e-06 0 2e-06 -0.2 2.2e-06 -0.18 2.4e-06 -0.16 2.6e-06 -0.14
+ 2.8e-06 -0.12 3e-06 -0.1 3.2e-06 -0.08 3.4e-06 -0.06 3.6e-06 -0.04 3.8e-06 -0.02
+ 4e-06 0 4.2e-06 0.02 4.4e-06 0.04 4.6e-06 0.06 4.8e-06 0.08 5e-06 0.1
+ 5.2e-06 0.12 5.4e-06 0.14 5.6e-06 0.16 5.8e-06 0.18 6e-06 0.2 6.2e-06 0.22
+ 6.4e-06 0.24 6.6e-06 0.26 6.8e-06 0.28 7e-06 0.3 7.2e-06 0.32 7.4e-06 0.34
+ 7.6e-06 0.36 7.8e-06 0.38 8e-06 0.4 8.2e-06 0.42 8.4e-06 0.44 8.6e-06 0.46
+ 8.8e-06 0.48 9e-06 0.5 9.2e-06 0.52 9.4e-06 0.54 9.6e-06 0.56 9.8e-06 0.58
+ 1e-05 0.6 1.02e-05 0.62 1.04e-05 0.64 1.06e-05 0.66 1.08e-05 0.68 1.1e-05 0.7
+ 1.12e-05 0.72 1.14e-05 0.74 1.16e-05 0.76 1.18e-05 0.78 1.2e-05 0.8 1.22e-05 0.82
+ 1.24e-05 0.84 1.26e-05 0.86 1.28e-05 0.88 1.3e-05 0.9 1.32e-05 0.92 1.34e-05 0.94
+ 1.36e-05 0.96 1.38e-05 0.98 1.4e-05 1 1.42e-05 1.02 1.44e-05 1.04 1.46e-05 1.06
+ 1.48e-05 1.08 1.5e-05 1.1 1.52e-05 1.12 1.54e-05 1.14 1.56e-05 1.16 1.58e-05 1.18
+ 1.6e-05 1.2 1.62e-05 1.22 1.64e-05 1.24 1.66e-05 1.26 1.68e-05 1.28 1.7e-05 1.3
+ 1.72e-05 1.32 1.74e-05 1.34 1.76e-05 1.36 1.78e-05 1.38 1.8e-05 1.4 1.82e-05 1.42
+ 1.84e-05 1.44 1.86e-05 1.46 1.88e-05 1.48 1.9e-05 1.5 1.92e-05 1.52 1.94e-05 1.54
+ 1.96e-05 1.56 1.98e-05 1.58 2e-05 1.6 2.02e-05 1.62 2.04e-05 1.64 2.06e-05 1.66
+ 2.08e-05 1.68 2.1e-05 1.7 2.12e-05 1.72 2.14e-05 1.74 2.16e-05 1.76 2.18e-05 1.78
+ 2.2e-05 1.8 2.22e-05 1.82 2.24e-05 1.84 2.26e-05 1.86 2.28e-05 1.88 2.3e-05 1.9
+ 2.32e-05 1.92 2.34e-05 1.94 2.36e-05 1.96 2.38e-05 1.98 2.4e-05 2 2.42e-05 2.02
+ 2.44e-05 2.04 2.46e-05 2.06 2.48e-05 2.08 2.5e-05 2.1 2.52e-05 2.12 2.54e-05 2.14
+ 2.56e-05 2.16 2.58e-05 2.18 2.6e-05 2.2 2.62e-05 2.22 2.64e-05 2.24 2.66e-05 2.26
+ 2.68e-05 2.28 2.7e-05 2.3 2.72e-05 2.32 2.74e-05 2.34 2.76e-05 2.36 2.78e-05 2.38
+ 2.8e-05 2.4 2.9e-05 0)
Vd_r1c2l d_r1c2l 0 pwl(
+ 0 0 4e-07 0 5e-07 0.05 2.91e-05 0.05 2.92e-05 0)
Xr1c2l g_r1c2l d_r1c2l 0 0 fefet_c16 x0_1=-0.999276974 x0_2=-0.963360144 x0_3=-0.867091747 x0_4=-0.730133867 x0_5=-0.571807384 x0_6=-0.40492262
+ x0_7=-0.237640667 x0_8=-0.074609272 x0_9=0.0811871949 x0_10=0.228444308 x0_11=0.36635266 x0_12=0.494806973
+ x0_13=0.61409885 x0_14=0.724945713 x0_15=0.828795173 x0_16=0.930424416
.ic v(xr1c2l.m)=-0.0138685264
Vg_r1c2r g_r1c2r 0 pwl(
+ 0 0 1e-06 0 2e-06 -0.2 2.2e-06 -0.18 2.4e-06 -0.16 2.6e-06 -0.14
+ 2.8e-06 -0.12 3e-06 -0.1 3.2e-06 -0.08 3.4e-06 -0.06 3.6e-06 -0.04 3.8e-06 -0.02
+ 4e-06 0 4.2e-06 0.02 4.4e-06 0.04 4.6e-06 0.06 4.8e-06 0.08 5e-06 0.1
+ 5.2e-06 0.12 5.4e-06 0.14 5.6e-06 0.16 5.8e-06 0.18 6e-06 0.2 6.2e-06 0.22
+ 6.4e-06 0.24 6.6e-06 0.26 6.8e-06 0.28 7e-06 0.3 7.2e-06 0.32 7.4e-06 0.34
+ 7.6e-06 0.36 7.8e-06 0.38 8e-06 0.4 8.2e-06 0.42 8.4e-06 0.44 8.6e-06 0.46
+ 8.8e-06 0.48 9e-06 0.5 9.2e-06 0.52 9.4e-06 0.54 9.6e-06 0.56 9.8e-06 0.58
+ 1e-05 0.6 1.02e-05 0.62 1.04e-05 0.64 1.06e-05 0.66 1.08e-05 0.68 1.1e-05 0.7
+ 1.12e-05 0.72 1.14e-05 0.74 1.16e-05 0.76 1.18e-05 0.78 1.2e-05 0.8 1.22e-05 0.82
+ 1.24e-05 0.84 1.26e-05 0.86 1.28e-05 0.88 1.3e-05 0.9 1.32e-05 0.92 1.34e-05 0.94
+ 1.36e-05 0.96 1.38e-05 0.98 1.4e-05 1 1.42e-05 1.02 1.44e-05 1.04 1.46e-05 1.06
+ 1.48e-05 1.08 1.5e-05 1.1 1.52e-05 1.12 1.54e-05 1.14 1.56e-05 1.16 1.58e-05 1.18
+ 1.6e-05 1.2 1.62e-05 1.22 1.64e-05 1.24 1.66e-05 1.26 1.68e-05 1.28 1.7e-05 1.3
+ 1.72e-05 1.32 1.74e-05 1.34 1.76e-05 1.36 1.78e-05 1.38 1.8e-05 1.4 1.82e-05 1.42
+ 1.84e-05 1.44 1.86e-05 1.46 1.88e-05 1.48 1.9e-05 1.5 1.92e-05 1.52 1.94e-05 1.54
+ 1.96e-05 1.56 1.98e-05 1.58 2e-05 1.6 2.02e-05 1.62 2.04e-05 1.64 2.06e-05 1.66
+ 2.08e-05 1.68 2.1e-05 1.7 2.12e-05 1.72 2.14e-05 1.74 2.16e-05 1.76 2.18e-05 1.78
+ 2.2e-05 1.8 2.22e-05 1.82 2.24e-05 1.84 2.26e-05 1.86 2.28e-05 1.88 2.3e-05 1.9
+ 2.32e-05 1.92 2.34e-05 1.94 2.36e-05 1.96 2.38e-05 1.98 2.4e-05 2 2.42e-05 2.02
+ 2.44e-05 2.04 2.46e-05 2.06 2.48e-05 2.08 2.5e-05 2.1 2.52e-05 2.12 2.54e-05 2.14
+ 2.56e-05 2.16 2.58e-05 2.18 2.6e-05 2.2 2.62e-05 2.22 2.64e-05 2.24 2.66e-05 2.26
+ 2.68e-05 2.28 2.7e-05 2.3 2.72e-05 2.32 2.74e-05 2.34 2.76e-05 2.36 2.78e-05 2.38
+ 2.8e-05 2.4 2.9e-05 0)
Vd_r1c2r d_r1c2r 0 pwl(
+ 0 0 4e-07 0 5e-07 0.05 2.91e-05 0.05 2.92e-05 0)
Xr1c2r g_r1c2r d_r1c2r 0 0 fefet_c16 x0_1=-0.998768253 x0_2=-0.999758157 x0_3=-0.999910837 x0_4=-0.999959796 x0_5=-0.99998005 x0_6=-0.999989598
+ x0_7=-0.999994445 x0_8=-0.99999702 x0_9=-0.999998418 x0_10=-0.999999183 x0_11=-0.999999598 x0_12=-0.999999816
+ x0_13=-0.999999926 x0_14=-0.999999976 x0_15=-0.999999995 x0_16=-1
.ic v(xr1c2r.m)=-0.277128463
Vg_r1c3l g_r1c3l 0 pwl(
+ 0 0 1e-06 0 2e-06 -0.2 2.2e-06 -0.18 2.4e-06 -0.16 2.6e-06 -0.14
+ 2.8e-06 -0.12 3e-06 -0.1 3.2e-06 -0.08 3.4e-06 -0.06 3.6e-06 -0.04 3.8e-06 -0.02
+ 4e-06 0 4.2e-06 0.02 4.4e-06 0.04 4.6e-06 0.06 4.8e-06 0.08 5e-06 0.1
+ 5.2e-06 0.12 5.4e-06 0.14 5.6e-06 0.16 5.8e-06 0.18 6e-06 0.2 6.2e-06 0.22
+ 6.4e-06 0.24 6.6e-06 0.26 6.8e-06 0.28 7e-06 0.3 7.2e-06 0.32 7.4e-06 0.34
+ 7.6e-06 0.36 7.8e-06 0.38 8e-06 0.4 8.2e-06 0.42 8.4e-06 0.44 8.6e-06 0.46
+ 8.8e-06 0.48 9e-06 0.5 9.2e-06 0.52 9.4e-06 0.54 9.6e-06 0.56 9.8e-06 0.58
+ 1e-05 0.6 1.02e-05 0.62 1.04e-05 0.64 1.06e-05 0.66 1.08e-05 0.68 1.1e-05 0.7
+ 1.12e-05 0.72 1.14e-05 0.74 1.16e-05 0.76 1.18e-05 0.78 1.2e-05 0.8 1.22e-05 0.82
+ 1.24e-05 0.84 1.26e-05 0.86 1.28e-05 0.88 1.3e-05 0.9 1.32e-05 0.92 1.34e-05 0.94
+ 1.36e-05 0.96 1.38e-05 0.98 1.4e-05 1 1.42e-05 1.02 1.44e-05 1.04 1.46e-05 1.06
+ 1.48e-05 1.08 1.5e-05 1.1 1.52e-05 1.12 1.54e-05 1.14 1.56e-05 1.16 1.58e-05 1.18
+ 1.6e-05 1.2 1.62e-05 1.22 1.64e-05 1.24 1.66e-05 1.26 1.68e-05 1.28 1.7e-05 1.3
+ 1.72e-05 1.32 1.74e-05 1.34 1.76e-05 1.36 1.78e-05 1.38 1.8e-05 1.4 1.82e-05 1.42
+ 1.84e-05 1.44 1.86e-05 1.46 1.88e-05 1.48 1.9e-05 1.5 1.92e-05 1.52 1.94e-05 1.54
+ 1.96e-05 1.56 1.98e-05 1.58 2e-05 1.6 2.02e-05 1.62 2.04e-05 1.64 2.06e-05 1.66
+ 2.08e-05 1.68 2.1e-05 1.7 2.12e-05 1.72 2.14e-05 1.74 2.16e-05 1.76 2.18e-05 1.78
+ 2.2e-05 1.8 2.22e-05 1.82 2.24e-05 1.84 2.26e-05 1.86 2.28e-05 1.88 2.3e-05 1.9
+ 2.32e-05 1.92 2.34e-05 1.94 2.36e-05 1.96 2.38e-05 1.98 2.4e-05 2 2.42e-05 2.02
+ 2.44e-05 2.04 2.46e-05 2.06 2.48e-05 2.08 2.5e-05 2.1 2.52e-05 2.12 2.54e-05 2.14
+ 2.56e-05 2.16 2.58e-05 2.18 2.6e-05 2.2 2.62e-05 2.22 2.64e-05 2.24 2.66e-05 2.26
+ 2.68e-05 2.28 2.7e-05 2.3 2.72e-05 2.32 2.74e-05 2.34 2.76e-05 2.36 2.78e-05 2.38
+ 2.8e-05 2.4 2.9e-05 0)
Vd_r1c3l d_r1c3l 0 pwl(
+ 0 0 4e-07 0 5e-07 0.05 2.91e-05 0.05 2.92e-05 0)
Xr1c3l g_r1c3l d_r1c3l 0 0 fefet_c16 x0_1=-0.999276974 x0_2=-0.963360144 x0_3=-0.867091747 x0_4=-0.730133867 x0_5=-0.571807384 x0_6=-0.40492262
+ x0_7=-0.237640667 x0_8=-0.074609272 x0_9=0.0811871949 x0_10=0.228444308 x0_11=0.36635266 x0_12=0.494806973
+ x0_13=0.61409885 x0_14=0.724945713 x0_15=0.828795173 x0_16=0.930424416
.ic v(xr1c3l.m)=-0.0138685264
Vg_r1c3r g_r1c3r 0 pwl(
+ 0 0 1e-06 0 2e-06 -0.2 2.2e-06 -0.18 2.4e-06 -0.16 2.6e-06 -0.14
+ 2.8e-06 -0.12 3e-06 -0.1 3.2e-06 -0.08 3.4e-06 -0.06 3.6e-06 -0.04 3.8e-06 -0.02
+ 4e-06 0 4.2e-06 0.02 4.4e-06 0.04 4.6e-06 0.06 4.8e-06 0.08 5e-06 0.1
+ 5.2e-06 0.12 5.4e-06 0.14 5.6e-06 0.16 5.8e-06 0.18 6e-06 0.2 6.2e-06 0.22
+ 6.4e-06 0.24 6.6e-06 0.26 6.8e-06 0.28 7e-06 0.3 7.2e-06 0.32 7.4e-06 0.34
+ 7.6e-06 0.36 7.8e-06 0.38 8e-06 0.4 8.2e-06 0.42 8.4e-06 0.44 8.6e-06 0.46
+ 8.8e-06 0.48 9e-06 0.5 9.2e-06 0.52 9.4e-06 0.54 9.6e-06 0.56 9.8e-06 0.58
+ 1e-05 0.6 1.02e-05 0.62 1.04e-05 0.64 1.06e-05 0.66 1.08e-05 0.68 1.1e-05 0.7
+ 1.12e-05 0.72 1.14e-05 0.74 1.16e-05 0.76 1.18e-05 0.78 1.2e-05 0.8 1.22e-05 0.82
+ 1.24e-05 0.84 1.26e-05 0.86 1.28e-05 0.88 1.3e-05 0.9 1.32e-05 0.92 1.34e-05 0.94
+ 1.36e-05 0.96 1.38e-05 0.98 1.4e-05 1 1.42e-05 1.02 1.44e-05 1.04 1.46e-05 1.06
+ 1.48e-05 1.08 1.5e-05 1.1 1.52e-05 1.12 1.54e-05 1.14 1.56e-05 1.16 1.58e-05 1.18
+ 1.6e-05 1.2 1.62e-05 1.22 1.64e-05 1.24 1.66e-05 1.26 1.68e-05 1.28 1.7e-05 1.3
+ 1.72e-05 1.32 1.74e-05 1.34 1.76e-05 1.36 1.78e-05 1.38 1.8e-05 1.4 1.82e-05 1.42
+ 1.84e-05 1.44 1.86e-05 1.46 1.88e-05 1.48 1.9e-05 1.5 1.92e-05 1.52 1.94e-05 1.54
+ 1.96e-05 1.56 1.98e-05 1.58 2e-05 1.6 2.02e-05 1.62 2.04e-05 1.64 2.06e-05 1.66
+ 2.08e-05 1.68 2.1e-05 1.7 2.12e-05 1.72 2.14e-05 1.74 2.16e-05 1.76 2.18e-05 1.78
+ 2.2e-05 1.8 2.22e-05 1.82 2.24e-05 1.84 2.26e-05 1.86 2.28e-05 1.88 2.3e-05 1.9
+ 2.32e-05 1.92 2.34e-05 1.94 2.36e-05 1.96 2.38e-05 1.98 2.4e-05 2 2.42e-05 2.02
+ 2.44e-05 2.04 2.46e-05 2.06 2.48e-05 2.08 2.5e-05 2.1 2.52e-05 2.12 2.54e-05 2.14
+ 2.56e-05 2.16 2.58e-05 2.18 2.6e-05 2.2 2.62e-05 2.22 2.64e-05 2.24 2.66e-05 2.26
+ 2.68e-05 2.28 2.7e-05 2.3 2.72e-05 2.32 2.74e-05 2.34 2.76e-05 2.36 2.78e-05 2.38
+ 2.8e-05 2.4 2.9e-05 0)
Vd_r1c3r d_r1c3r 0 pwl(
+ 0 0 4e-07 0 5e-07 0.05 2.91e-05 0.05 2.92e-05 0)
Xr1c3r g_r1c3r d_r1c3r 0 0 fefet_c16 x0_1=-0.998768253 x0_2=-0.999758157 x0_3=-0.999910837 x0_4=-0.999959796 x0_5=-0.99998005 x0_6=-0.999989598
+ x0_7=-0.999994445 x0_8=-0.99999702 x0_9=-0.999998418 x0_10=-0.999999183 x0_11=-0.999999598 x0_12=-0.999999816
+ x0_13=-0.999999926 x0_14=-0.999999976 x0_15=-0.999999995 x0_16=-1
.ic v(xr1c3r.m)=-0.277128463
Vg_r1c4l g_r1c4l 0 pwl(
+ 0 0 1e-06 0 2e-06 -0.2 2.2e-06 -0.18 2.4e-06 -0.16 2.6e-06 -0.14
+ 2.8e-06 -0.12 3e-06 -0.1 3.2e-06 -0.08 3.4e-06 -0.06 3.6e-06 -0.04 3.8e-06 -0.02
+ 4e-06 0 4.2e-06 0.02 4.4e-06 0.04 4.6e-06 0.06 4.8e-06 0.08 5e-06 0.1
+ 5.2e-06 0.12 5.4e-06 0.14 5.6e-06 0.16 5.8e-06 0.18 6e-06 0.2 6.2e-06 0.22
+ 6.4e-06 0.24 6.6e-06 0.26 6.8e-06 0.28 7e-06 0.3 7.2e-06 0.32 7.4e-06 0.34
+ 7.6e-06 0.36 7.8e-06 0.38 8e-06 0.4 8.2e-06 0.42 8.4e-06 0.44 8.6e-06 0.46
+ 8.8e-06 0.48 9e-06 0.5 9.2e-06 0.52 9.4e-06 0.54 9.6e-06 0.56 9.8e-06 0.58
+ 1e-05 0.6 1.02e-05 0.62 1.04e-05 0.64 1.06e-05 0.66 1.08e-05 0.68 1.1e-05 0.7
+ 1.12e-05 0.72 1.14e-05 0.74 1.16e-05 0.76 1.18e-05 0.78 1.2e-05 0.8 1.22e-05 0.82
+ 1.24e-05 0.84 1.26e-05 0.86 1.28e-05 0.88 1.3e-05 0.9 1.32e-05 0.92 1.34e-05 0.94
+ 1.36e-05 0.96 1.38e-05 0.98 1.4e-05 1 1.42e-05 1.02 1.44e-05 1.04 1.46e-05 1.06
+ 1.48e-05 1.08 1.5e-05 1.1 1.52e-05 1.12 1.54e-05 1.14 1.56e-05 1.16 1.58e-05 1.18
+ 1.6e-05 1.2 1.62e-05 1.22 1.64e-05 1.24 1.66e-05 1.26 1.68e-05 1.28 1.7e-05 1.3
+ 1.72e-05 1.32 1.74e-05 1.34 1.76e-05 1.36 1.78e-05 1.38 1.8e-05 1.4 1.82e-05 1.42
+ 1.84e-05 1.44 1.86e-05 1.46 1.88e-05 1.48 1.9e-05 1.5 1.92e-05 1.52 1.94e-05 1.54
+ 1.96e-05 1.56 1.98e-05 1.58 2e-05 1.6 2.02e-05 1.62 2.04e-05 1.64 2.06e-05 1.66
+ 2.08e-05 1.68 2.1e-05 1.7 2.12e-05 1.72 2.14e-05 1.74 2.16e-05 1.76 2.18e-05 1.78
+ 2.2e-05 1.8 2.22e-05 1.82 2.24e-05 1.84 2.26e-05 1.86 2.28e-05 1.88 2.3e-05 1.9
+ 2.32e-05 1.92 2.34e-05 1.94 2.36e-05 1.96 2.38e-05 1.98 2.4e-05 2 2.42e-05 2.02
+ 2.44e-05 2.04 2.46e-05 2.06 2.48e-05 2.08 2.5e-05 2.1 2.52e-05 2.12 2.54e-05 2.14
+ 2.56e-05 2.16 2.58e-05 2.18 2.6e-05 2.2 2.62e-05 2.22 2.64e-05 2.24 2.66e-05 2.26
+ 2.68e-05 2.28 2.7e-05 2.3 2.72e-05 2.32 2.74e-05 2.34 2.76e-05 2.36 2.78e-05 2.38
+ 2.8e-05 2.4 2.9e-05 0)
Vd_r1c4l d_r1c4l 0 pwl(
+ 0 0 4e-07 0 5e-07 0.05 2.91e-05 0.05 2.92e-05 0)
Xr1c4l g_r1c4l d_r1c4l 0 0 fefet_c16 x0_1=-0.999896945 x0_2=-0.999979767 x0_3=-0.99999254 x0_4=-0.999996636 x0_5=-0.999998331 x0_6=-0.99999913
+ x0_7=-0.999999535 x0_8=-0.999999751 x0_9=-0.999999868 x0_10=-0.999999932 x0_11=-0.999999966 x0_12=-0.999999985
+ x0_13=-0.999999994 x0_14=-0.999999998 x0_15=-1 x0_16=-1
.ic v(xr1c4l.m)=-0.277154474
Vg_r1c4r g_r1c4r 0 pwl(
+ 0 0 1e-06 0 2e-06 -0.2 2.2e-06 -0.18 2.4e-06 -0.16 2.6e-06 -0.14
+ 2.8e-06 -0.12 3e-06 -0.1 3.2e-06 -0.08 3.4e-06 -0.06 3.6e-06 -0.04 3.8e-06 -0.02
+ 4e-06 0 4.2e-06 0.02 4.4e-06 0.04 4.6e-06 0.06 4.8e-06 0.08 5e-06 0.1
+ 5.2e-06 0.12 5.4e-06 0.14 5.6e-06 0.16 5.8e-06 0.18 6e-06 0.2 6.2e-06 0.22
+ 6.4e-06 0.24 6.6e-06 0.26 6.8e-06 0.28 7e-06 0.3 7.2e-06 0.32 7.4e-06 0.34
+ 7.6e-06 0.36 7.8e-06 0.38 8e-06 0.4 8.2e-06 0.42 8.4e-06 0.44 8.6e-06 0.46
+ 8.8e-06 0.48 9e-06 0.5 9.2e-06 0.52 9.4e-06 0.54 9.6e-06 0.56 9.8e-06 0.58
+ 1e-05 0.6 1.02e-05 0.62 1.04e-05 0.64 1.06e-05 0.66 1.08e-05 0.68 1.1e-05 0.7
+ 1.12e-05 0.72 1.14e-05 0.74 1.16e-05 0.76 1.18e-05 0.78 1.2e-05 0.8 1.22e-05 0.82
+ 1.24e-05 0.84 1.26e-05 0.86 1.28e-05 0.88 1.3e-05 0.9 1.32e-05 0.92 1.34e-05 0.94
+ 1.36e-05 0.96 1.38e-05 0.98 1.4e-05 1 1.42e-05 1.02 1.44e-05 1.04 1.46e-05 1.06
+ 1.48e-05 1.08 1.5e-05 1.1 1.52e-05 1.12 1.54e-05 1.14 1.56e-05 1.16 1.58e-05 1.18
+ 1.6e-05 1.2 1.62e-05 1.22 1.64e-05 1.24 1.66e-05 1.26 1.68e-05 1.28 1.7e-05 1.3
+ 1.72e-05 1.32 1.74e-05 1.34 1.76e-05 1.36 1.78e-05 1.38 1.8e-05 1.4 1.82e-05 1.42
+ 1.84e-05 1.44 1.86e-05 1.46 1.88e-05 1.48 1.9e-05 1.5 1.92e-05 1.52 1.94e-05 1.54
+ 1.96e-05 1.56 1.98e-05 1.58 2e-05 1.6 2.02e-05 1.62 2.04e-05 1.64 2.06e-05 1.66
+ 2.08e-05 1.68 2.1e-05 1.7 2.12e-05 1.72 2.14e-05 1.74 2.16e-05 1.76 2.18e-05 1.78
+ 2.2e-05 1.8 2.22e-05 1.82 2.24e-05 1.84 2.26e-05 1.86 2.28e-05 1.88 2.3e-05 1.9
+ 2.32e-05 1.92 2.34e-05 1.94 2.36e-05 1.96 2.38e-05 1.98 2.4e-05 2 2.42e-05 2.02
+ 2.44e-05 2.04 2.46e-05 2.06 2.48e-05 2.08 2.5e-05 2.1 2.52e-05 2.12 2.54e-05 2.14
+ 2.56e-05 2.16 2.58e-05 2.18 2.6e-05 2.2 2.62e-05 2.22 2.64e-05 2.24 2.66e-05 2.26
+ 2.68e-05 2.28 2.7e-05 2.3 2.72e-05 2.32 2.74e-05 2.34 2.76e-05 2.36 2.78e-05 2.38
+ 2.8e-05 2.4 2.9e-05 0)
Vd_r1c4r d_r1c4r 0 pwl(
+ 0 0 4e-07 0 5e-07 0.05 2.91e-05 0.05 2.92e-05 0)
Xr1c4r g_r1c4r d_r1c4r 0 0 fefet_c16 x0_1=-0.999276974 x0_2=-0.963360144 x0_3=-0.867091747 x0_4=-0.730133867 x0_5=-0.571807384 x0_6=-0.40492262
+ x0_7=-0.237640667 x0_8=-0.074609272 x0_9=0.0811871949 x0_10=0.228444308 x0_11=0.36635266 x0_12=0.494806973
+ x0_13=0.61409885 x0_14=0.724945713 x0_15=0.828795173 x0_16=0.930424416
.ic v(xr1c4r.m)=-0.0138685264
Vg_r1c5l g_r1c5l 0 pwl(
+ 0 0 1e-06 0 2e-06 -0.2 2.2e-06 -0.18 2.4e-06 -0.16 2.6e-06 -0.14
+ 2.8e-06 -0.12 3e-06 -0.1 3.2e-06 -0.08 3.4e-06 -0.06 3.6e-06 -0.04 3.8e-06 -0.02
+ 4e-06 0 4.2e-06 0.02 4.4e-06 0.04 4.6e-06 0.06 4.8e-06 0.08 5e-06 0.1
+ 5.2e-06 0.12 5.4e-06 0.14 5.6e-06 0.16 5.8e-06 0.18 6e-06 0.2 6.2e-06 0.22
+ 6.4e-06 0.24 6.6e-06 0.26 6.8e-06 0.28 7e-06 0.3 7.2e-06 0.32 7.4e-06 0.34
+ 7.6e-06 0.36 7.8e-06 0.38 8e-06 0.4 8.2e-06 0.42 8.4e-06 0.44 8.6e-06 0.46
+ 8.8e-06 0.48 9e-06 0.5 9.2e-06 0.52 9.4e-06 0.54 9.6e-06 0.56 9.8e-06 0.58
+ 1e-05 0.6 1.02e-05 0.62 1.04e-05 0.64 1.06e-05 0.66 1.08e-05 0.68 1.1e-05 0.7
+ 1.12e-05 0.72 1.14e-05 0.74 1.16e-05 0.76 1.18e-05 0.78 1.2e-05 0.8 1.22e-05 0.82
+ 1.24e-05 0.84 1.26e-05 0.86 1.28e-05 0.88 1.3e-05 0.9 1.32e-05 0.92 1.34e-05 0.94
+ 1.36e-05 0.96 1.38e-05 0.98 1.4e-05 1 1.42e-05 1.02 1.44e-05 1.04 1.46e-05 1.06
+ 1.48e-05 1.08 1.5e-05 1.1 1.52e-05 1.12 1.54e-05 1.14 1.56e-05 1.16 1.58e-05 1.18
+ 1.6e-05 1.2 1.62e-05 1.22 1.64e-05 1.24 1.66e-05 1.26 1.68e-05 1.28 1.7e-05 1.3
+ 1.72e-05 1.32 1.74e-05 1.34 1.76e-05 1.36 1.78e-05 1.38 1.8e-05 1.4 1.82e-05 1.42
+ 1.84e-05 1.44 1.86e-05 1.46 1.88e-05 1.48 1.9e-05 1.5 1.92e-05 1.52 1.94e-05 1.54
+ 1.96e-05 1.56 1.98e-05 1.58 2e-05 1.6 2.02e-05 1.62 2.04e-05 1.64 2.06e-05 1.66
+ 2.08e-05 1.68 2.1e-05 1.7 2.12e-05 1.72 2.14e-05 1.74 2.16e-05 1.76 2.18e-05 1.78
+ 2.2e-05 1.8 2.22e-05 1.82 2.24e-05 1.84 2.26e-05 1.86 2.28e-05 1.88 2.3e-05 1.9
+ 2.32e-05 1.92 2.34e-05 1.94 2.36e-05 1.96 2.38e-05 1.98 2.4e-05 2 2.42e-05 2.02
+ 2.44e-05 2.04 2.46e-05 2.06 2.48e-05 2.08 2.5e-05 2.1 2.52e-05 2.12 2.54e-05 2.14
+ 2.56e-05 2.16 2.58e-05 2.18 2.6e-05 2.2 2.62e-05 2.22 2.64e-05 2.24 2.66e-05 2.26
+ 2.68e-05 2.28 2.7e-05 2.3 2.72e-05 2.32 2.74e-05 2.34 2.76e-05 2.36 2.78e-05 2.38
+ 2.8e-05 2.4 2.9e-05 0)
Vd_r1c5l d_r1c5l 0 pwl(
+ 0 0 4e-07 0 5e-07 0.05 2.91e-05 0.05 2.92e-05 0)
Xr1c5l g_r1c5l d_r1c5l 0 0 fefet_c16 x0_1=-0.999896945 x0_2=-0.999979767 x0_3=-0.99999254 x0_4=-0.999996636 x0_5=-0.999998331 x0_6=-0.99999913
+ x0_7=-0.999999535 x0_8=-0.999999751 x0_9=-0.999999868 x0_10=-0.999999932 x0_11=-0.999999966 x0_12=-0.999999985
+ x0_13=-0.999999994 x0_14=-0.999999998 x0_15=-1 x0_16=-1
.ic v(xr1c5l.m)=-0.277154474
Vg_r1c5r g_r1c5r 0 pwl(
+ 0 0 1e-06 0 2e-06 -0.2 2.2e-06 -0.18 2.4e-06 -0.16 2.6e-06 -0.14
+ 2.8e-06 -0.12 3e-06 -0.1 3.2e-06 -0.08 3.4e-06 -0.06 3.6e-06 -0.04 3.8e-06 -0.02
+ 4e-06 0 4.2e-06 0.02 4.4e-06 0.04 4.6e-06 0.06 4.8e-06 0.08 5e-06 0.1
+ 5.2e-06 0.12 5.4e-06 0.14 5.6e-06 0.16 5.8e-06 0.18 6e-06 0.2 6.2e-06 0.22
+ 6.4e-06 0.24 6.6e-06 0.26 6.8e-06 0.28 7e-06 0.3 7.2e-06 0.32 7.4e-06 0.34
+ 7.6e-06 0.36 7.8e-06 0.38 8e-06 0.4 8.2e-06 0.42 8.4e-06 0.44 8.6e-06 0.46
+ 8.8e-06 0.48 9e-06 0.5 9.2e-06 0.52 9.4e-06 0.54 9.6e-06 0.56 9.8e-06 0.58
+ 1e-05 0.6 1.02e-05 0.62 1.04e-05 0.64 1.06e-05 0.66 1.08e-05 0.68 1.1e-05 0.7
+ 1.12e-05 0.72 1.14e-05 0.74 1.16e-05 0.76 1.18e-05 0.78 1.2e-05 0.8 1.22e-05 0.82
+ 1.24e-05 0.84 1.26e-05 0.86 1.28e-05 0.88 1.3e-05 0.9 1.32e-05 0.92 1.34e-05 0.94
+ 1.36e-05 0.96 1.38e-05 0.98 1.4e-05 1 1.42e-05 1.02 1.44e-05 1.04 1.46e-05 1.06
+ 1.48e-05 1.08 1.5e-05 1.1 1.52e-05 1.12 1.54e-05 1.14 1.56e-05 1.16 1.58e-05 1.18
+ 1.6e-05 1.2 1.62e-05 1.22 1.64e-05 1.24 1.66e-05 1.26 1.68e-05 1.28 1.7e-05 1.3
+ 1.72e-05 1.32 1.74e-05 1.34 1.76e-05 1.36 1.78e-05 1.38 1.8e-05 1.4 1.82e-05 1.42
+ 1.84e-05 1.44 1.86e-05 1.46 1.88e-05 1.48 1.9e-05 1.5 1.92e-05 1.52 1.94e-05 1.54
+ 1.96e-05 1.56 1.98e-05 1.58 2e-05 1.6 2.02e-05 1.62 2.04e-05 1.64 2.06e-05 1.66
+ 2.08e-05 1.68 2.1e-05 1.7 2.12e-05 1.72 2.14e-05 1.74 2.16e-05 1.76 2.18e-05 1.78
+ 2.2e-05 1.8 2.22e-05 1.82 2.24e-05 1.84 2.26e-05 1.86 2.28e-05 1.88 2.3e-05 1.9
+ 2.32e-05 1.92 2.34e-05 1.94 2.36e-05 1.96 2.38e-05 1.98 2.4e-05 2 2.42e-05 2.02
+ 2.44e-05 2.04 2.46e-05 2.06 2.48e-05 2.08 2.5e-05 2.1 2.52e-05 2.12 2.54e-05 2.14
+ 2.56e-05 2.16 2.58e-05 2.18 2.6e-05 2.2 2.62e-05 2.22 2.64e-05 2.24 2.66e-05 2.26
+ 2.68e-05 2.28 2.7e-05 2.3 2.72e-05 2.32 2.74e-05 2.34 2.76e-05 2.36 2.78e-05 2.38
+ 2.8e-05 2.4 2.9e-05 0)
Vd_r1c5r d_r1c5r 0 pwl(
+ 0 0 4e-07 0 5e-07 0.05 2.91e-05 0.05 2.92e-05 0)
Xr1c5r g_r1c5r d_r1c5r 0 0 fefet_c16 x0_1=-0.998768253 x0_2=-0.999758157 x0_3=-0.999910837 x0_4=-0.999959796 x0_5=-0.99998005 x0_6=-0.999989598
+ x0_7=-0.999994445 x0_8=-0.99999702 x0_9=-0.999998418 x0_10=-0.999999183 x0_11=-0.999999598 x0_12=-0.999999816
+ x0_13=-0.999999926 x0_14=-0.999999976 x0_15=-0.999999995 x0_16=-1
.ic v(xr1c5r.m)=-0.277128463
Vg_r1c6l g_r1c6l 0 pwl(
+ 0 0 1e-06 0 2e-06 -0.2 2.2e-06 -0.18 2.4e-06 -0.16 2.6e-06 -0.14
+ 2.8e-06 -0.12 3e-06 -0.1 3.2e-06 -0.08 3.4e-06 -0.06 3.6e-06 -0.04 3.8e-06 -0.02
+ 4e-06 0 4.2e-06 0.02 4.4e-06 0.04 4.6e-06 0.06 4.8e-06 0.08 5e-06 0.1
+ 5.2e-06 0.12 5.4e-06 0.14 5.6e-06 0.16 5.8e-06 0.18 6e-06 0.2 6.2e-06 0.22
+ 6.4e-06 0.24 6.6e-06 0.26 6.8e-06 0.28 7e-06 0.3 7.2e-06 0.32 7.4e-06 0.34
+ 7.6e-06 0.36 7.8e-06 0.38 8e-06 0.4 8.2e-06 0.42 8.4e-06 0.44 8.6e-06 0.46
+ 8.8e-06 0.48 9e-06 0.5 9.2e-06 0.52 9.4e-06 0.54 9.6e-06 0.56 9.8e-06 0.58
+ 1e-05 0.6 1.02e-05 0.62 1.04e-05 0.64 1.06e-05 0.66 1.08e-05 0.68 1.1e-05 0.7
+ 1.12e-05 0.72 1.14e-05 0.74 1.16e-05 0.76 1.18e-05 0.78 1.2e-05 0.8 1.22e-05 0.82
+ 1.24e-05 0.84 1.26e-05 0.86 1.28e-05 0.88 1.3e-05 0.9 1.32e-05 0.92 1.34e-05 0.94
+ 1.36e-05 0.96 1.38e-05 0.98 1.4e-05 1 1.42e-05 1.02 1.44e-05 1.04 1.46e-05 1.06
+ 1.48e-05 1.08 1.5e-05 1.1 1.52e-05 1.12 1.54e-05 1.14 1.56e-05 1.16 1.58e-05 1.18
+ 1.6e-05 1.2 1.62e-05 1.22 1.64e-05 1.24 1.66e-05 1.26 1.68e-05 1.28 1.7e-05 1.3
+ 1.72e-05 1.32 1.74e-05 1.34 1.76e-05 1.36 1.78e-05 1.38 1.8e-05 1.4 1.82e-05 1.42
+ 1.84e-05 1.44 1.86e-05 1.46 1.88e-05 1.48 1.9e-05 1.5 1.92e-05 1.52 1.94e-05 1.54
+ 1.96e-05 1.56 1.98e-05 1.58 2e-05 1.6 2.02e-05 1.62 2.04e-05 1.64 2.06e-05 1.66
+ 2.08e-05 1.68 2.1e-05 1.7 2.12e-05 1.72 2.14e-05 1.74 2.16e-05 1.76 2.18e-05 1.78
+ 2.2e-05 1.8 2.22e-05 1.82 2.24e-05 1.84 2.26e-05 1.86 2.28e-05 1.88 2.3e-05 1.9
+ 2.32e-05 1.92 2.34e-05 1.94 2.36e-05 1.96 2.38e-05 1.98 2.4e-05 2 2.42e-05 2.02
+ 2.44e-05 2.04 2.46e-05 2.06 2.48e-05 2.08 2.5e-05 2.1 2.52e-05 2.12 2.54e-05 2.14
+ 2.56e-05 2.16 2.58e-05 2.18 2.6e-05 2.2 2.62e-05 2.22 2.64e-05 2.24 2.66e-05 2.26
+ 2.68e-05 2.28 2.7e-05 2.3 2.72e-05 2.32 2.74e-05 2.34 2.76e-05 2.36 2.78e-05 2.38
+ 2.8e-05 2.4 2.9e-05 0)
Vd_r1c6l d_r1c6l 0 pwl(
+ 0 0 4e-07 0 5e-07 0.05 2.91e-05 0.05 2.92e-05 0)
Xr1c6l g_r1c6l d_r1c6l 0 0 fefet_c16 x0_1=-0.998768253 x0_2=-0.999758157 x0_3=-0.999910837 x0_4=-0.999959796 x0_5=-0.99998005 x0_6=-0.999989598
+ x0_7=-0.999994445 x0_8=-0.99999702 x0_9=-0.999998418 x0_10=-0.999999183 x0_11=-0.999999598 x0_12=-0.999999816
+ x0_13=-0.999999926 x0_14=-0.999999976 x0_15=-0.999999995 x0_16=-1
.ic v(xr1c6l.m)=-0.277128463
Vg_r1c6r g_r1c6r 0 pwl(
+ 0 0 1e-06 0 2e-06 -0.2 2.2e-06 -0.18 2.4e-06 -0.16 2.6e-06 -0.14
+ 2.8e-06 -0.12 3e-06 -0.1 3.2e-06 -0.08 3.4e-06 -0.06 3.6e-06 -0.04 3.8e-06 -0.02
+ 4e-06 0 4.2e-06 0.02 4.4e-06 0.04 4.6e-06 0.06 4.8e-06 0.08 5e-06 0.1
+ 5.2e-06 0.12 5.4e-06 0.14 5.6e-06 0.16 5.8e-06 0.18 6e-06 0.2 6.2e-06 0.22
+ 6.4e-06 0.24 6.6e-06 0.26 6.8e-06 0.28 7e-06 0.3 7.2e-06 0.32 7.4e-06 0.34
+ 7.6e-06 0.36 7.8e-06 0.38 8e-06 0.4 8.2e-06 0.42 8.4e-06 0.44 8.6e-06 0.46
+ 8.8e-06 0.48 9e-06 0.5 9.2e-06 0.52 9.4e-06 0.54 9.6e-06 0.56 9.8e-06 0.58
+ 1e-05 0.6 1.02e-05 0.62 1.04e-05 0.64 1.06e-05 0.66 1.08e-05 0.68 1.1e-05 0.7
+ 1.12e-05 0.72 1.14e-05 0.74 1.16e-05 0.76 1.18e-05 0.78 1.2e-05 0.8 1.22e-05 0.82
+ 1.24e-05 0.84 1.26e-05 0.86 1.28e-05 0.88 1.3e-05 0.9 1.32e-05 0.92 1.34e-05 0.94
+ 1.36e-05 0.96 1.38e-05 0.98 1.4e-05 1 1.42e-05 1.02 1.44e-05 1.04 1.46e-05 1.06
+ 1.48e-05 1.08 1.5e-05 1.1 1.52e-05 1.12 1.54e-05 1.14 1.56e-05 1.16 1.58e-05 1.18
+ 1.6e-05 1.2 1.62e-05 1.22 1.64e-05 1.24 1.66e-05 1.26 1.68e-05 1.28 1.7e-05 1.3
+ 1.72e-05 1.32 1.74e-05 1.34 1.76e-05 1.36 1.78e-05 1.38 1.8e-05 1.4 1.82e-05 1.42
+ 1.84e-05 1.44 1.86e-05 1.46 1.88e-05 1.48 1.9e-05 1.5 1.92e-05 1.52 1.94e-05 1.54
+ 1.96e-05 1.56 1.98e-05 1.58 2e-05 1.6 2.02e-05 1.62 2.04e-05 1.64 2.06e-05 1.66
+ 2.08e-05 1.68 2.1e-05 1.7 2.12e-05 1.72 2.14e-05 1.74 2.16e-05 1.76 2.18e-05 1.78
+ 2.2e-05 1.8 2.22e-05 1.82 2.24e-05 1.84 2.26e-05 1.86 2.28e-05 1.88 2.3e-05 1.9
+ 2.32e-05 1.92 2.34e-05 1.94 2.36e-05 1.96 2.38e-05 1.98 2.4e-05 2 2.42e-05 2.02
+ 2.44e-05 2.04 2.46e-05 2.06 2.48e-05 2.08 2.5e-05 2.1 2.52e-05 2.12 2.54e-05 2.14
+ 2.56e-05 2.16 2.58e-05 2.18 2.6e-05 2.2 2.62e-05 2.22 2.64e-05 2.24 2.66e-05 2.26
+ 2.68e-05 2.28 2.7e-05 2.3 2.72e-05 2.32 2.74e-05 2.34 2.76e-05 2.36 2.78e-05 2.38
+ 2.8e-05 2.4 2.9e-05 0)
Vd_r1c6r d_r1c6r 0 pwl(
+ 0 0 4e-07 0 5e-07 0.05 2.91e-05 0.05 2.92e-05 0)
Xr1c6r g_r1c6r d_r1c6r 0 0 fefet_c16 x0_1=-0.999276974 x0_2=-0.963360144 x0_3=-0.867091747 x0_4=-0.730133867 x0_5=-0.571807384 x0_6=-0.40492262
+ x0_7=-0.237640667 x0_8=-0.074609272 x0_9=0.0811871949 x0_10=0.228444308 x0_11=0.36635266 x0_12=0.494806973
+ x0_13=0.61409885 x0_14=0.724945713 x0_15=0.828795173 x0_16=0.930424416
.ic v(xr1c6r.m)=-0.0138685264
Vg_r1c7l g_r1c7l 0 pwl(
+ 0 0 1e-06 0 2e-06 -0.2 2.2e-06 -0.18 2.4e-06 -0.16 2.6e-06 -0.14
+ 2.8e-06 -0.12 3e-06 -0.1 3.2e-06 -0.08 3.4e-06 -0.06 3.6e-06 -0.04 3.8e-06 -0.02
+ 4e-06 0 4.2e-06 0.02 4.4e-06 0.04 4.6e-06 0.06 4.8e-06 0.08 5e-06 0.1
+ 5.2e-06 0.12 5.4e-06 0.14 5.6e-06 0.16 5.8e-06 0.18 6e-06 0.2 6.2e-06 0.22
+ 6.4e-06 0.24 6.6e-06 0.26 6.8e-06 0.28 7e-06 0.3 7.2e-06 0.32 7.4e-06 0.34
+ 7.6e-06 0.36 7.8e-06 0.38 8e-06 0.4 8.2e-06 0.42 8.4e-06 0.44 8.6e-06 0.46
+ 8.8e-06 0.48 9e-06 0.5 9.2e-06 0.52 9.4e-06 0.54 9.6e-06 0.56 9.8e-06 0.58
+ 1e-05 0.6 1.02e-05 0.62 1.04e-05 0.64 1.06e-05 0.66 1.08e-05 0.68 1.1e-05 0.7
+ 1.12e-05 0.72 1.14e-05 0.74 1.16e-05 0.76 1.18e-05 0.78 1.2e-05 0.8 1.22e-05 0.82
+ 1.24e-05 0.84 1.26e-05 0.86 1.28e-05 0.88 1.3e-05 0.9 1.32e-05 0.92 1.34e-05 0.94
+ 1.36e-05 0.96 1.38e-05 0.98 1.4e-05 1 1.42e-05 1.02 1.44e-05 1.04 1.46e-05 1.06
+ 1.48e-05 1.08 1.5e-05 1.1 1.52e-05 1.12 1.54e-05 1.14 1.56e-05 1.16 1.58e-05 1.18
+ 1.6e-05 1.2 1.62e-05 1.22 1.64e-05 1.24 1.66e-05 1.26 1.68e-05 1.28 1.7e-05 1.3
+ 1.72e-05 1.32 1.74e-05 1.34 1.76e-05 1.36 1.78e-05 1.38 1.8e-05 1.4 1.82e-05 1.42
+ 1.84e-05 1.44 1.86e-05 1.46 1.88e-05 1.48 1.9e-05 1.5 1.92e-05 1.52 1.94e-05 1.54
+ 1.96e-05 1.56 1.98e-05 1.58 2e-05 1.6 2.02e-05 1.62 2.04e-05 1.64 2.06e-05 1.66
+ 2.08e-05 1.68 2.1e-05 1.7 2.12e-05 1.72 2.14e-05 1.74 2.16e-05 1.76 2.18e-05 1.78
+ 2.2e-05 1.8 2.22e-05 1.82 2.24e-05 1.84 2.26e-05 1.86 2.28e-05 1.88 2.3e-05 1.9
+ 2.32e-05 1.92 2.34e-05 1.94 2.36e-05 1.96 2.38e-05 1.98 2.4e-05 2 2.42e-05 2.02
+ 2.44e-05 2.04 2.46e-05 2.06 2.48e-05 2.08 2.5e-05 2.1 2.52e-05 2.12 2.54e-05 2.14
+ 2.56e-05 2.16 2.58e-05 2.18 2.6e-05 2.2 2.62e-05 2.22 2.64e-05 2.24 2.66e-05 2.26
+ 2.68e-05 2.28 2.7e-05 2.3 2.72e-05 2.32 2.74e-05 2.34 2.76e-05 2.36 2.78e-05 2.38
+ 2.8e-05 2.4 2.9e-05 0)
Vd_r1c7l d_r1c7l 0 pwl(
+ 0 0 4e-07 0 5e-07 0.05 2.91e-05 0.05 2.92e-05 0)
Xr1c7l g_r1c7l d_r1c7l 0 0 fefet_c16 x0_1=-0.998768253 x0_2=-0.999758157 x0_3=-0.999910837 x0_4=-0.999959796 x0_5=-0.99998005 x0_6=-0.999989598
+ x0_7=-0.999994445 x0_8=-0.99999702 x0_9=-0.999998418 x0_10=-0.999999183 x0_11=-0.999999598 x0_12=-0.999999816
+ x0_13=-0.999999926 x0_14=-0.999999976 x0_15=-0.999999995 x0_16=-1
.ic v(xr1c7l.m)=-0.277128463
Vg_r1c7r g_r1c7r 0 pwl(
+ 0 0 1e-06 0 2e-06 -0.2 2.2e-06 -0.18 2.4e-06 -0.16 2.6e-06 -0.14
+ 2.8e-06 -0.12 3e-06 -0.1 3.2e-06 -0.08 3.4e-06 -0.06 3.6e-06 -0.04 3.8e-06 -0.02
+ 4e-06 0 4.2e-06 0.02 4.4e-06 0.04 4.6e-06 0.06 4.8e-06 0.08 5e-06 0.1
+ 5.2e-06 0.12 5.4e-06 0.14 5.6e-06 0.16 5.8e-06 0.18 6e-06 0.2 6.2e-06 0.22
+ 6.4e-06 0.24 6.6e-06 0.26 6.8e-06 0.28 7e-06 0.3 7.2e-06 0.32 7.4e-06 0.34
+ 7.6e-06 0.36 7.8e-06 0.38 8e-06 0.4 8.2e-06 0.42 8.4e-06 0.44 8.6e-06 0.46
+ 8.8e-06 0.48 9e-06 0.5 9.2e-06 0.52 9.4e-06 0.54 9.6e-06 0.56 9.8e-06 0.58
+ 1e-05 0.6 1.02e-05 0.62 1.04e-05 0.64 1.06e-05 0.66 1.08e-05 0.68 1.1e-05 0.7
+ 1.12e-05 0.72 1.14e-05 0.74 1.16e-05 0.76 1.18e-05 0.78 1.2e-05 0.8 1.22e-05 0.82
+ 1.24e-05 0.84 1.26e-05 0.86 1.28e-05 0.88 1.3e-05 0.9 1.32e-05 0.92 1.34e-05 0.94
+ 1.36e-05 0.96 1.38e-05 0.98 1.4e-05 1 1.42e-05 1.02 1.44e-05 1.04 1.46e-05 1.06
+ 1.48e-05 1.08 1.5e-05 1.1 1.52e-05 1.12 1.54e-05 1.14 1.56e-05 1.16 1.58e-05 1.18
+ 1.6e-05 1.2 1.62e-05 1.22 1.64e-05 1.24 1.66e-05 1.26 1.68e-05 1.28 1.7e-05 1.3
+ 1.72e-05 1.32 1.74e-05 1.34 1.76e-05 1.36 1.78e-05 1.38 1.8e-05 1.4 1.82e-05 1.42
+ 1.84e-05 1.44 1.86e-05 1.46 1.88e-05 1.48 1.9e-05 1.5 1.92e-05 1.52 1.94e-05 1.54
+ 1.96e-05 1.56 1.98e-05 1.58 2e-05 1.6 2.02e-05 1.62 2.04e-05 1.64 2.06e-05 1.66
+ 2.08e-05 1.68 2.1e-05 1.7 2.12e-05 1.72 2.14e-05 1.74 2.16e-05 1.76 2.18e-05 1.78
+ 2.2e-05 1.8 2.22e-05 1.82 2.24e-05 1.84 2.26e-05 1.86 2.28e-05 1.88 2.3e-05 1.9
+ 2.32e-05 1.92 2.34e-05 1.94 2.36e-05 1.96 2.38e-05 1.98 2.4e-05 2 2.42e-05 2.02
+ 2.44e-05 2.04 2.46e-05 2.06 2.48e-05 2.08 2.5e-05 2.1 2.52e-05 2.12 2.54e-05 2.14
+ 2.56e-05 2.16 2.58e-05 2.18 2.6e-05 2.2 2.62e-05 2.22 2.64e-05 2.24 2.66e-05 2.26
+ 2.68e-05 2.28 2.7e-05 2.3 2.72e-05 2.32 2.74e-05 2.34 2.76e-05 2.36 2.78e-05 2.38
+ 2.8e-05 2.4 2.9e-05 0)
Vd_r1c7r d_r1c7r 0 pwl(
+ 0 0 4e-07 0 5e-07 0.05 2.91e-05 0.05 2.92e-05 0)
Xr1c7r g_r1c7r d_r1c7r 0 0 fefet_c16 x0_1=-0.999276974 x0_2=-0.963360144 x0_3=-0.867091747 x0_4=-0.730133867 x0_5=-0.571807384 x0_6=-0.40492262
+ x0_7=-0.237640667 x0_8=-0.074609272 x0_9=0.0811871949 x0_10=0.228444308 x0_11=0.36635266 x0_12=0.494806973
+ x0_13=0.61409885 x0_14=0.724945713 x0_15=0.828795173 x0_16=0.930424416
.ic v(xr1c7r.m)=-0.0138685264
Vg_dlp g_dlp 0 pwl(
+ 0 0 1e-06 0 2e-06 -0.2 2.2e-06 -0.18 2.4e-06 -0.16 2.6e-06 -0.14
+ 2.8e-06 -0.12 3e-06 -0.1 3.2e-06 -0.08 3.4e-06 -0.06 3.6e-06 -0.04 3.8e-06 -0.02
+ 4e-06 0 4.2e-06 0.02 4.4e-06 0.04 4.6e-06 0.06 4.8e-06 0.08 5e-06 0.1
+ 5.2e-06 0.12 5.4e-06 0.14 5.6e-06 0.16 5.8e-06 0.18 6e-06 0.2 6.2e-06 0.22
+ 6.4e-06 0.24 6.6e-06 0.26 6.8e-06 0.28 7e-06 0.3 7.2e-06 0.32 7.4e-06 0.34
+ 7.6e-06 0.36 7.8e-06 0.38 8e-06 0.4 8.2e-06 0.42 8.4e-06 0.44 8.6e-06 0.46
+ 8.8e-06 0.48 9e-06 0.5 9.2e-06 0.52 9.4e-06 0.54 9.6e-06 0.56 9.8e-06 0.58
+ 1e-05 0.6 1.02e-05 0.62 1.04e-05 0.64 1.06e-05 0.66 1.08e-05 0.68 1.1e-05 0.7
+ 1.12e-05 0.72 1.14e-05 0.74 1.16e-05 0.76 1.18e-05 0.78 1.2e-05 0.8 1.22e-05 0.82
+ 1.24e-05 0.84 1.26e-05 0.86 1.28e-05 0.88 1.3e-05 0.9 1.32e-05 0.92 1.34e-05 0.94
+ 1.36e-05 0.96 1.38e-05 0.98 1.4e-05 1 1.42e-05 1.02 1.44e-05 1.04 1.46e-05 1.06
+ 1.48e-05 1.08 1.5e-05 1.1 1.52e-05 1.12 1.54e-05 1.14 1.56e-05 1.16 1.58e-05 1.18
+ 1.6e-05 1.2 1.62e-05 1.22 1.64e-05 1.24 1.66e-05 1.26 1.68e-05 1.28 1.7e-05 1.3
+ 1.72e-05 1.32 1.74e-05 1.34 1.76e-05 1.36 1.78e-05 1.38 1.8e-05 1.4 1.82e-05 1.42
+ 1.84e-05 1.44 1.86e-05 1.46 1.88e-05 1.48 1.9e-05 1.5 1.92e-05 1.52 1.94e-05 1.54
+ 1.96e-05 1.56 1.98e-05 1.58 2e-05 1.6 2.02e-05 1.62 2.04e-05 1.64 2.06e-05 1.66
+ 2.08e-05 1.68 2.1e-05 1.7 2.12e-05 1.72 2.14e-05 1.74 2.16e-05 1.76 2.18e-05 1.78
+ 2.2e-05 1.8 2.22e-05 1.82 2.24e-05 1.84 2.26e-05 1.86 2.28e-05 1.88 2.3e-05 1.9
+ 2.32e-05 1.92 2.34e-05 1.94 2.36e-05 1.96 2.38e-05 1.98 2.4e-05 2 2.42e-05 2.02
+ 2.44e-05 2.04 2.46e-05 2.06 2.48e-05 2.08 2.5e-05 2.1 2.52e-05 2.12 2.54e-05 2.14
+ 2.56e-05 2.16 2.58e-05 2.18 2.6e-05 2.2 2.62e-05 2.22 2.64e-05 2.24 2.66e-05 2.26
+ 2.68e-05 2.28 2.7e-05 2.3 2.72e-05 2.32 2.74e-05 2.34 2.76e-05 2.36 2.78e-05 2.38
+ 2.8e-05 2.4 2.9e-05 0)
Vd_dlp d_dlp 0 pwl(
+ 0 0 4e-07 0 5e-07 0.05 2.91e-05 0.05 2.92e-05 0)
Xdlp g_dlp d_dlp 0 0 fefet_c16 x0_1=1 x0_2=1 x0_3=1 x0_4=1 x0_5=1 x0_6=1
+ x0_7=1 x0_8=1 x0_9=1 x0_10=1 x0_11=1 x0_12=1
+ x0_13=1 x0_14=0.999999988 x0_15=1.00000021 x0_16=0.999959662
.ic v(xdlp.m)=0.424809906
Vg_dlm g_dlm 0 pwl(
+ 0 0 1e-06 0 2e-06 -0.2 2.2e-06 -0.18 2.4e-06 -0.16 2.6e-06 -0.14
+ 2.8e-06 -0.12 3e-06 -0.1 3.2e-06 -0.08 3.4e-06 -0.06 3.6e-06 -0.04 3.8e-06 -0.02
+ 4e-06 0 4.2e-06 0.02 4.4e-06 0.04 4.6e-06 0.06 4.8e-06 0.08 5e-06 0.1
+ 5.2e-06 0.12 5.4e-06 0.14 5.6e-06 0.16 5.8e-06 0.18 6e-06 0.2 6.2e-06 0.22
+ 6.4e-06 0.24 6.6e-06 0.26 6.8e-06 0.28 7e-06 0.3 7.2e-06 0.32 7.4e-06 0.34
+ 7.6e-06 0.36 7.8e-06 0.38 8e-06 0.4 8.2e-06 0.42 8.4e-06 0.44 8.6e-06 0.46
+ 8.8e-06 0.48 9e-06 0.5 9.2e-06 0.52 9.4e-06 0.54 9.6e-06 0.56 9.8e-06 0.58
+ 1e-05 0.6 1.02e-05 0.62 1.04e-05 0.64 1.06e-05 0.66 1.08e-05 0.68 1.1e-05 0.7
+ 1.12e-05 0.72 1.14e-05 0.74 1.16e-05 0.76 1.18e-05 0.78 1.2e-05 0.8 1.22e-05 0.82
+ 1.24e-05 0.84 1.26e-05 0.86 1.28e-05 0.88 1.3e-05 0.9 1.32e-05 0.92 1.34e-05 0.94
+ 1.36e-05 0.96 1.38e-05 0.98 1.4e-05 1 1.42e-05 1.02 1.44e-05 1.04 1.46e-05 1.06
+ 1.48e-05 1.08 1.5e-05 1.1 1.52e-05 1.12 1.54e-05 1.14 1.56e-05 1.16 1.58e-05 1.18
+ 1.6e-05 1.2 1.62e-05 1.22 1.64e-05 1.24 1.66e-05 1.26 1.68e-05 1.28 1.7e-05 1.3
+ 1.72e-05 1.32 1.74e-05 1.34 1.76e-05 1.36 1.78e-05 1.38 1.8e-05 1.4 1.82e-05 1.42
+ 1.84e-05 1.44 1.86e-05 1.46 1.88e-05 1.48 1.9e-05 1.5 1.92e-05 1.52 1.94e-05 1.54
+ 1.96e-05 1.56 1.98e-05 1.58 2e-05 1.6 2.02e-05 1.62 2.04e-05 1.64 2.06e-05 1.66
+ 2.08e-05 1.68 2.1e-05 1.7 2.12e-05 1.72 2.14e-05 1.74 2.16e-05 1.76 2.18e-05 1.78
+ 2.2e-05 1.8 2.22e-05 1.82 2.24e-05 1.84 2.26e-05 1.86 2.28e-05 1.88 2.3e-05 1.9
+ 2.32e-05 1.92 2.34e-05 1.94 2.36e-05 1.96 2.38e-05 1.98 2.4e-05 2 2.42e-05 2.02
+ 2.44e-05 2.04 2.46e-05 2.06 2.48e-05 2.08 2.5e-05 2.1 2.52e-05 2.12 2.54e-05 2.14
+ 2.56e-05 2.16 2.58e-05 2.18 2.6e-05 2.2 2.62e-05 2.22 2.64e-05 2.24 2.66e-05 2.26
+ 2.68e-05 2.28 2.7e-05 2.3 2.72e-05 2.32 2.74e-05 2.34 2.76e-05 2.36 2.78e-05 2.38
+ 2.8e-05 2.4 2.9e-05 0)
Vd_dlm d_dlm 0 pwl(
+ 0 0 4e-07 0 5e-07 0.05 2.91e-05 0.05 2.92e-05 0)
Xdlm g_dlm d_dlm 0 0 fefet_c16 x0_1=-1 x0_2=-1.00000009 x0_3=-0.999995093 x0_4=-1.00004691 x0_5=-0.997766665 x0_6=-0.979630765
+ x0_7=-0.922328207 x0_8=-0.807523089 x0_9=-0.632779831 x0_10=-0.41014354 x0_11=-0.159920404 x0_12=0.0968438137
+ x0_13=0.342511862 x0_14=0.564609657 x0_15=0.755890149 x0_16=0.915357776
.ic v(xdlm.m)=-0.124506058
Vg_dhp g_dhp 0 pwl(
+ 0 0 1e-06 0 2e-06 -0.2 2.2e-06 -0.18 2.4e-06 -0.16 2.6e-06 -0.14
+ 2.8e-06 -0.12 3e-06 -0.1 3.2e-06 -0.08 3.4e-06 -0.06 3.6e-06 -0.04 3.8e-06 -0.02
+ 4e-06 0 4.2e-06 0.02 4.4e-06 0.04 4.6e-06 0.06 4.8e-06 0.08 5e-06 0.1
+ 5.2e-06 0.12 5.4e-06 0.14 5.6e-06 0.16 5.8e-06 0.18 6e-06 0.2 6.2e-06 0.22
+ 6.4e-06 0.24 6.6e-06 0.26 6.8e-06 0.28 7e-06 0.3 7.2e-06 0.32 7.4e-06 0.34
+ 7.6e-06 0.36 7.8e-06 0.38 8e-06 0.4 8.2e-06 0.42 8.4e-06 0.44 8.6e-06 0.46
+ 8.8e-06 0.48 9e-06 0.5 9.2e-06 0.52 9.4e-06 0.54 9.6e-06 0.56 9.8e-06 0.58
+ 1e-05 0.6 1.02e-05 0.62 1.04e-05 0.64 1.06e-05 0.66 1.08e-05 0.68 1.1e-05 0.7
+ 1.12e-05 0.72 1.14e-05 0.74 1.16e-05 0.76 1.18e-05 0.78 1.2e-05 0.8 1.22e-05 0.82
+ 1.24e-05 0.84 1.26e-05 0.86 1.28e-05 0.88 1.3e-05 0.9 1.32e-05 0.92 1.34e-05 0.94
+ 1.36e-05 0.96 1.38e-05 0.98 1.4e-05 1 1.42e-05 1.02 1.44e-05 1.04 1.46e-05 1.06
+ 1.48e-05 1.08 1.5e-05 1.1 1.52e-05 1.12 1.54e-05 1.14 1.56e-05 1.16 1.58e-05 1.18
+ 1.6e-05 1.2 1.62e-05 1.22 1.64e-05 1.24 1.66e-05 1.26 1.68e-05 1.28 1.7e-05 1.3
+ 1.72e-05 1.32 1.74e-05 1.34 1.76e-05 1.36 1.78e-05 1.38 1.8e-05 1.4 1.82e-05 1.42
+ 1.84e-05 1.44 1.86e-05 1.46 1.88e-05 1.48 1.9e-05 1.5 1.92e-05 1.52 1.94e-05 1.54
+ 1.96e-05 1.56 1.98e-05 1.58 2e-05 1.6 2.02e-05 1.62 2.04e-05 1.64 2.06e-05 1.66
+ 2.08e-05 1.68 2.1e-05 1.7 2.12e-05 1.72 2.14e-05 1.74 2.16e-05 1.76 2.18e-05 1.78
+ 2.2e-05 1.8 2.22e-05 1.82 2.24e-05 1.84 2.26e-05 1.86 2.28e-05 1.88 2.3e-05 1.9
+ 2.32e-05 1.92 2.34e-05 1.94 2.36e-05 1.96 2.38e-05 1.98 2.4e-05 2 2.42e-05 2.02
+ 2.44e-05 2.04 2.46e-05 2.06 2.48e-05 2.08 2.5e-05 2.1 2.52e-05 2.12 2.54e-05 2.14
+ 2.56e-05 2.16 2.58e-05 2.18 2.6e-05 2.2 2.62e-05 2.22 2.64e-05 2.24 2.66e-05 2.26
+ 2.68e-05 2.28 2.7e-05 2.3 2.72e-05 2.32 2.74e-05 2.34 2.76e-05 2.36 2.78e-05 2.38
+ 2.8e-05 2.4 2.9e-05 0)
Vd_dhp d_dhp 0 pwl(
+ 0 0 4e-07 0 5e-07 0.05 2.91e-05 0.05 2.92e-05 0)
Xdhp g_dhp d_dhp 0 0 fefet_c16 x0_1=-0.772562332 x0_2=-0.954035082 x0_3=-0.983122075 x0_4=-0.992440536 x0_5=-0.996274812 x0_6=-0.998070912
+ x0_7=-0.998976837 x0_8=-0.999454827 x0_9=-0.999712609 x0_10=-0.999852704 x0_11=-0.999928034 x0_12=-0.99996743
+ x0_13=-0.99998697 x0_14=-0.999995791 x0_15=-0.999999123 x0_16=-0.999999957
.ic v(xdhp.m)=-0.272672006
Vg_dhm g_dhm 0 pwl(
+ 0 0 1e-06 0 2e-06 -0.2 2.2e-06 -0.18 2.4e-06 -0.16 2.6e-06 -0.14
+ 2.8e-06 -0.12 3e-06 -0.1 3.2e-06 -0.08 3.4e-06 -0.06 3.6e-06 -0.04 3.8e-06 -0.02
+ 4e-06 0 4.2e-06 0.02 4.4e-06 0.04 4.6e-06 0.06 4.8e-06 0.08 5e-06 0.1
+ 5.2e-06 0.12 5.4e-06 0.14 5.6e-06 0.16 5.8e-06 0.18 6e-06 0.2 6.2e-06 0.22
+ 6.4e-06 0.24 6.6e-06 0.26 6.8e-06 0.28 7e-06 0.3 7.2e-06 0.32 7.4e-06 0.34
+ 7.6e-06 0.36 7.8e-06 0.38 8e-06 0.4 8.2e-06 0.42 8.4e-06 0.44 8.6e-06 0.46
+ 8.8e-06 0.48 9e-06 0.5 9.2e-06 0.52 9.4e-06 0.54 9.6e-06 0.56 9.8e-06 0.58
+ 1e-05 0.6 1.02e-05 0.62 1.04e-05 0.64 1.06e-05 0.66 1.08e-05 0.68 1.1e-05 0.7
+ 1.12e-05 0.72 1.14e-05 0.74 1.16e-05 0.76 1.18e-05 0.78 1.2e-05 0.8 1.22e-05 0.82
+ 1.24e-05 0.84 1.26e-05 0.86 1.28e-05 0.88 1.3e-05 0.9 1.32e-05 0.92 1.34e-05 0.94
+ 1.36e-05 0.96 1.38e-05 0.98 1.4e-05 1 1.42e-05 1.02 1.44e-05 1.04 1.46e-05 1.06
+ 1.48e-05 1.08 1.5e-05 1.1 1.52e-05 1.12 1.54e-05 1.14 1.56e-05 1.16 1.58e-05 1.18
+ 1.6e-05 1.2 1.62e-05 1.22 1.64e-05 1.24 1.66e-05 1.26 1.68e-05 1.28 1.7e-05 1.3
+ 1.72e-05 1.32 1.74e-05 1.34 1.76e-05 1.36 1.78e-05 1.38 1.8e-05 1.4 1.82e-05 1.42
+ 1.84e-05 1.44 1.86e-05 1.46 1.88e-05 1.48 1.9e-05 1.5 1.92e-05 1.52 1.94e-05 1.54
+ 1.96e-05 1.56 1.98e-05 1.58 2e-05 1.6 2.02e-05 1.62 2.04e-05 1.64 2.06e-05 1.66
+ 2.08e-05 1.68 2.1e-05 1.7 2.12e-05 1.72 2.14e-05 1.74 2.16e-05 1.76 2.18e-05 1.78
+ 2.2e-05 1.8 2.22e-05 1.82 2.24e-05 1.84 2.26e-05 1.86 2.28e-05 1.88 2.3e-05 1.9
+ 2.32e-05 1.92 2.34e-05 1.94 2.36e-05 1.96 2.38e-05 1.98 2.4e-05 2 2.42e-05 2.02
+ 2.44e-05 2.04 2.46e-05 2.06 2.48e-05 2.08 2.5e-05 2.1 2.52e-05 2.12 2.54e-05 2.14
+ 2.56e-05 2.16 2.58e-05 2.18 2.6e-05 2.2 2.62e-05 2.22 2.64e-05 2.24 2.66e-05 2.26
+ 2.68e-05 2.28 2.7e-05 2.3 2.72e-05 2.32 2.74e-05 2.34 2.76e-05 2.36 2.78e-05 2.38
+ 2.8e-05 2.4 2.9e-05 0)
Vd_dhm d_dhm 0 pwl(
+ 0 0 4e-07 0 5e-07 0.05 2.91e-05 0.05 2.92e-05 0)
Xdhm g_dhm d_dhm 0 0 fefet_c16 x0_1=-1 x0_2=-1 x0_3=-1 x0_4=-1 x0_5=-1 x0_6=-1
+ x0_7=-1 x0_8=-1 x0_9=-1 x0_10=-1 x0_11=-1 x0_12=-1
+ x0_13=-1 x0_14=-1 x0_15=-1 x0_16=-1
.ic v(xdhm.m)=-0.277155151
Vg_dl0 g_dl0 0 pwl(
+ 0 0 1e-06 0 2e-06 -0.2 2.2e-06 -0.18 2.4e-06 -0.16 2.6e-06 -0.14
+ 2.8e-06 -0.12 3e-06 -0.1 3.2e-06 -0.08 3.4e-06 -0.06 3.6e-06 -0.04 3.8e-06 -0.02
+ 4e-06 0 4.2e-06 0.02 4.4e-06 0.04 4.6e-06 0.06 4.8e-06 0.08 5e-06 0.1
+ 5.2e-06 0.12 5.4e-06 0.14 5.6e-06 0.16 5.8e-06 0.18 6e-06 0.2 6.2e-06 0.22
+ 6.4e-06 0.24 6.6e-06 0.26 6.8e-06 0.28 7e-06 0.3 7.2e-06 0.32 7.4e-06 0.34
+ 7.6e-06 0.36 7.8e-06 0.38 8e-06 0.4 8.2e-06 0.42 8.4e-06 0.44 8.6e-06 0.46
+ 8.8e-06 0.48 9e-06 0.5 9.2e-06 0.52 9.4e-06 0.54 9.6e-06 0.56 9.8e-06 0.58
+ 1e-05 0.6 1.02e-05 0.62 1.04e-05 0.64 1.06e-05 0.66 1.08e-05 0.68 1.1e-05 0.7
+ 1.12e-05 0.72 1.14e-05 0.74 1.16e-05 0.76 1.18e-05 0.78 1.2e-05 0.8 1.22e-05 0.82
+ 1.24e-05 0.84 1.26e-05 0.86 1.28e-05 0.88 1.3e-05 0.9 1.32e-05 0.92 1.34e-05 0.94
+ 1.36e-05 0.96 1.38e-05 0.98 1.4e-05 1 1.42e-05 1.02 1.44e-05 1.04 1.46e-05 1.06
+ 1.48e-05 1.08 1.5e-05 1.1 1.52e-05 1.12 1.54e-05 1.14 1.56e-05 1.16 1.58e-05 1.18
+ 1.6e-05 1.2 1.62e-05 1.22 1.64e-05 1.24 1.66e-05 1.26 1.68e-05 1.28 1.7e-05 1.3
+ 1.72e-05 1.32 1.74e-05 1.34 1.76e-05 1.36 1.78e-05 1.38 1.8e-05 1.4 1.82e-05 1.42
+ 1.84e-05 1.44 1.86e-05 1.46 1.88e-05 1.48 1.9e-05 1.5 1.92e-05 1.52 1.94e-05 1.54
+ 1.96e-05 1.56 1.98e-05 1.58 2e-05 1.6 2.02e-05 1.62 2.04e-05 1.64 2.06e-05 1.66
+ 2.08e-05 1.68 2.1e-05 1.7 2.12e-05 1.72 2.14e-05 1.74 2.16e-05 1.76 2.18e-05 1.78
+ 2.2e-05 1.8 2.22e-05 1.82 2.24e-05 1.84 2.26e-05 1.86 2.28e-05 1.88 2.3e-05 1.9
+ 2.32e-05 1.92 2.34e-05 1.94 2.36e-05 1.96 2.38e-05 1.98 2.4e-05 2 2.42e-05 2.02
+ 2.44e-05 2.04 2.46e-05 2.06 2.48e-05 2.08 2.5e-05 2.1 2.52e-05 2.12 2.54e-05 2.14
+ 2.56e-05 2.16 2.58e-05 2.18 2.6e-05 2.2 2.62e-05 2.22 2.64e-05 2.24 2.66e-05 2.26
+ 2.68e-05 2.28 2.7e-05 2.3 2.72e-05 2.32 2.74e-05 2.34 2.76e-05 2.36 2.78e-05 2.38
+ 2.8e-05 2.4 2.9e-05 0)
Vd_dl0 d_dl0 0 pwl(
+ 0 0 4e-07 0 5e-07 0.05 2.91e-05 0.05 2.92e-05 0)
Xdl0 g_dl0 d_dl0 0 0 fefet_c16 x0_1=1 x0_2=1 x0_3=1 x0_4=1 x0_5=1 x0_6=1
+ x0_7=1 x0_8=1 x0_9=1 x0_10=1 x0_11=1 x0_12=1
+ x0_13=1 x0_14=0.999999988 x0_15=1.00000021 x0_16=0.999959662
.ic v(xdl0.m)=0.424804359
Vg_dh0 g_dh0 0 pwl(
+ 0 0 1e-06 0 2e-06 -0.2 2.2e-06 -0.18 2.4e-06 -0.16 2.6e-06 -0.14
+ 2.8e-06 -0.12 3e-06 -0.1 3.2e-06 -0.08 3.4e-06 -0.06 3.6e-06 -0.04 3.8e-06 -0.02
+ 4e-06 0 4.2e-06 0.02 4.4e-06 0.04 4.6e-06 0.06 4.8e-06 0.08 5e-06 0.1
+ 5.2e-06 0.12 5.4e-06 0.14 5.6e-06 0.16 5.8e-06 0.18 6e-06 0.2 6.2e-06 0.22
+ 6.4e-06 0.24 6.6e-06 0.26 6.8e-06 0.28 7e-06 0.3 7.2e-06 0.32 7.4e-06 0.34
+ 7.6e-06 0.36 7.8e-06 0.38 8e-06 0.4 8.2e-06 0.42 8.4e-06 0.44 8.6e-06 0.46
+ 8.8e-06 0.48 9e-06 0.5 9.2e-06 0.52 9.4e-06 0.54 9.6e-06 0.56 9.8e-06 0.58
+ 1e-05 0.6 1.02e-05 0.62 1.04e-05 0.64 1.06e-05 0.66 1.08e-05 0.68 1.1e-05 0.7
+ 1.12e-05 0.72 1.14e-05 0.74 1.16e-05 0.76 1.18e-05 0.78 1.2e-05 0.8 1.22e-05 0.82
+ 1.24e-05 0.84 1.26e-05 0.86 1.28e-05 0.88 1.3e-05 0.9 1.32e-05 0.92 1.34e-05 0.94
+ 1.36e-05 0.96 1.38e-05 0.98 1.4e-05 1 1.42e-05 1.02 1.44e-05 1.04 1.46e-05 1.06
+ 1.48e-05 1.08 1.5e-05 1.1 1.52e-05 1.12 1.54e-05 1.14 1.56e-05 1.16 1.58e-05 1.18
+ 1.6e-05 1.2 1.62e-05 1.22 1.64e-05 1.24 1.66e-05 1.26 1.68e-05 1.28 1.7e-05 1.3
+ 1.72e-05 1.32 1.74e-05 1.34 1.76e-05 1.36 1.78e-05 1.38 1.8e-05 1.4 1.82e-05 1.42
+ 1.84e-05 1.44 1.86e-05 1.46 1.88e-05 1.48 1.9e-05 1.5 1.92e-05 1.52 1.94e-05 1.54
+ 1.96e-05 1.56 1.98e-05 1.58 2e-05 1.6 2.02e-05 1.62 2.04e-05 1.64 2.06e-05 1.66
+ 2.08e-05 1.68 2.1e-05 1.7 2.12e-05 1.72 2.14e-05 1.74 2.16e-05 1.76 2.18e-05 1.78
+ 2.2e-05 1.8 2.22e-05 1.82 2.24e-05 1.84 2.26e-05 1.86 2.28e-05 1.88 2.3e-05 1.9
+ 2.32e-05 1.92 2.34e-05 1.94 2.36e-05 1.96 2.38e-05 1.98 2.4e-05 2 2.42e-05 2.02
+ 2.44e-05 2.04 2.46e-05 2.06 2.48e-05 2.08 2.5e-05 2.1 2.52e-05 2.12 2.54e-05 2.14
+ 2.56e-05 2.16 2.58e-05 2.18 2.6e-05 2.2 2.62e-05 2.22 2.64e-05 2.24 2.66e-05 2.26
+ 2.68e-05 2.28 2.7e-05 2.3 2.72e-05 2.32 2.74e-05 2.34 2.76e-05 2.36 2.78e-05 2.38
+ 2.8e-05 2.4 2.9e-05 0)
Vd_dh0 d_dh0 0 pwl(
+ 0 0 4e-07 0 5e-07 0.05 2.91e-05 0.05 2.92e-05 0)
Xdh0 g_dh0 d_dh0 0 0 fefet_c16 x0_1=-1 x0_2=-1 x0_3=-1 x0_4=-1 x0_5=-1 x0_6=-1
+ x0_7=-1 x0_8=-1 x0_9=-1 x0_10=-1 x0_11=-1 x0_12=-1
+ x0_13=-1 x0_14=-1 x0_15=-1 x0_16=-1
.ic v(xdh0.m)=-0.277154442
Vg_dlp3 g_dlp3 0 pwl(
+ 0 0 1e-06 0 2e-06 -0.2 2.2e-06 -0.18 2.4e-06 -0.16 2.6e-06 -0.14
+ 2.8e-06 -0.12 3e-06 -0.1 3.2e-06 -0.08 3.4e-06 -0.06 3.6e-06 -0.04 3.8e-06 -0.02
+ 4e-06 0 4.2e-06 0.02 4.4e-06 0.04 4.6e-06 0.06 4.8e-06 0.08 5e-06 0.1
+ 5.2e-06 0.12 5.4e-06 0.14 5.6e-06 0.16 5.8e-06 0.18 6e-06 0.2 6.2e-06 0.22
+ 6.4e-06 0.24 6.6e-06 0.26 6.8e-06 0.28 7e-06 0.3 7.2e-06 0.32 7.4e-06 0.34
+ 7.6e-06 0.36 7.8e-06 0.38 8e-06 0.4 8.2e-06 0.42 8.4e-06 0.44 8.6e-06 0.46
+ 8.8e-06 0.48 9e-06 0.5 9.2e-06 0.52 9.4e-06 0.54 9.6e-06 0.56 9.8e-06 0.58
+ 1e-05 0.6 1.02e-05 0.62 1.04e-05 0.64 1.06e-05 0.66 1.08e-05 0.68 1.1e-05 0.7
+ 1.12e-05 0.72 1.14e-05 0.74 1.16e-05 0.76 1.18e-05 0.78 1.2e-05 0.8 1.22e-05 0.82
+ 1.24e-05 0.84 1.26e-05 0.86 1.28e-05 0.88 1.3e-05 0.9 1.32e-05 0.92 1.34e-05 0.94
+ 1.36e-05 0.96 1.38e-05 0.98 1.4e-05 1 1.42e-05 1.02 1.44e-05 1.04 1.46e-05 1.06
+ 1.48e-05 1.08 1.5e-05 1.1 1.52e-05 1.12 1.54e-05 1.14 1.56e-05 1.16 1.58e-05 1.18
+ 1.6e-05 1.2 1.62e-05 1.22 1.64e-05 1.24 1.66e-05 1.26 1.68e-05 1.28 1.7e-05 1.3
+ 1.72e-05 1.32 1.74e-05 1.34 1.76e-05 1.36 1.78e-05 1.38 1.8e-05 1.4 1.82e-05 1.42
+ 1.84e-05 1.44 1.86e-05 1.46 1.88e-05 1.48 1.9e-05 1.5 1.92e-05 1.52 1.94e-05 1.54
+ 1.96e-05 1.56 1.98e-05 1.58 2e-05 1.6 2.02e-05 1.62 2.04e-05 1.64 2.06e-05 1.66
+ 2.08e-05 1.68 2.1e-05 1.7 2.12e-05 1.72 2.14e-05 1.74 2.16e-05 1.76 2.18e-05 1.78
+ 2.2e-05 1.8 2.22e-05 1.82 2.24e-05 1.84 2.26e-05 1.86 2.28e-05 1.88 2.3e-05 1.9
+ 2.32e-05 1.92 2.34e-05 1.94 2.36e-05 1.96 2.38e-05 1.98 2.4e-05 2 2.42e-05 2.02
+ 2.44e-05 2.04 2.46e-05 2.06 2.48e-05 2.08 2.5e-05 2.1 2.52e-05 2.12 2.54e-05 2.14
+ 2.56e-05 2.16 2.58e-05 2.18 2.6e-05 2.2 2.62e-05 2.22 2.64e-05 2.24 2.66e-05 2.26
+ 2.68e-05 2.28 2.7e-05 2.3 2.72e-05 2.32 2.74e-05 2.34 2.76e-05 2.36 2.78e-05 2.38
+ 2.8e-05 2.4 2.9e-05 0)
Vd_dlp3 d_dlp3 0 pwl(
+ 0 0 4e-07 0 5e-07 0.05 2.91e-05 0.05 2.92e-05 0)
Xdlp3 g_dlp3 d_dlp3 0 0 fefet_c16 x0_1=1 x0_2=1 x0_3=1 x0_4=1 x0_5=1 x0_6=1
+ x0_7=1 x0_8=1 x0_9=1 x0_10=1 x0_11=1 x0_12=1
+ x0_13=1 x0_14=0.999999988 x0_15=1.00000021 x0_16=0.999959662
.ic v(xdlp3.m)=0.424804459
Vg_dlm3 g_dlm3 0 pwl(
+ 0 0 1e-06 0 2e-06 -0.2 2.2e-06 -0.18 2.4e-06 -0.16 2.6e-06 -0.14
+ 2.8e-06 -0.12 3e-06 -0.1 3.2e-06 -0.08 3.4e-06 -0.06 3.6e-06 -0.04 3.8e-06 -0.02
+ 4e-06 0 4.2e-06 0.02 4.4e-06 0.04 4.6e-06 0.06 4.8e-06 0.08 5e-06 0.1
+ 5.2e-06 0.12 5.4e-06 0.14 5.6e-06 0.16 5.8e-06 0.18 6e-06 0.2 6.2e-06 0.22
+ 6.4e-06 0.24 6.6e-06 0.26 6.8e-06 0.28 7e-06 0.3 7.2e-06 0.32 7.4e-06 0.34
+ 7.6e-06 0.36 7.8e-06 0.38 8e-06 0.4 8.2e-06 0.42 8.4e-06 0.44 8.6e-06 0.46
+ 8.8e-06 0.48 9e-06 0.5 9.2e-06 0.52 9.4e-06 0.54 9.6e-06 0.56 9.8e-06 0.58
+ 1e-05 0.6 1.02e-05 0.62 1.04e-05 0.64 1.06e-05 0.66 1.08e-05 0.68 1.1e-05 0.7
+ 1.12e-05 0.72 1.14e-05 0.74 1.16e-05 0.76 1.18e-05 0.78 1.2e-05 0.8 1.22e-05 0.82
+ 1.24e-05 0.84 1.26e-05 0.86 1.28e-05 0.88 1.3e-05 0.9 1.32e-05 0.92 1.34e-05 0.94
+ 1.36e-05 0.96 1.38e-05 0.98 1.4e-05 1 1.42e-05 1.02 1.44e-05 1.04 1.46e-05 1.06
+ 1.48e-05 1.08 1.5e-05 1.1 1.52e-05 1.12 1.54e-05 1.14 1.56e-05 1.16 1.58e-05 1.18
+ 1.6e-05 1.2 1.62e-05 1.22 1.64e-05 1.24 1.66e-05 1.26 1.68e-05 1.28 1.7e-05 1.3
+ 1.72e-05 1.32 1.74e-05 1.34 1.76e-05 1.36 1.78e-05 1.38 1.8e-05 1.4 1.82e-05 1.42
+ 1.84e-05 1.44 1.86e-05 1.46 1.88e-05 1.48 1.9e-05 1.5 1.92e-05 1.52 1.94e-05 1.54
+ 1.96e-05 1.56 1.98e-05 1.58 2e-05 1.6 2.02e-05 1.62 2.04e-05 1.64 2.06e-05 1.66
+ 2.08e-05 1.68 2.1e-05 1.7 2.12e-05 1.72 2.14e-05 1.74 2.16e-05 1.76 2.18e-05 1.78
+ 2.2e-05 1.8 2.22e-05 1.82 2.24e-05 1.84 2.26e-05 1.86 2.28e-05 1.88 2.3e-05 1.9
+ 2.32e-05 1.92 2.34e-05 1.94 2.36e-05 1.96 2.38e-05 1.98 2.4e-05 2 2.42e-05 2.02
+ 2.44e-05 2.04 2.46e-05 2.06 2.48e-05 2.08 2.5e-05 2.1 2.52e-05 2.12 2.54e-05 2.14
+ 2.56e-05 2.16 2.58e-05 2.18 2.6e-05 2.2 2.62e-05 2.22 2.64e-05 2.24 2.66e-05 2.26
+ 2.68e-05 2.28 2.7e-05 2.3 2.72e-05 2.32 2.74e-05 2.34 2.76e-05 2.36 2.78e-05 2.38
+ 2.8e-05 2.4 2.9e-05 0)
Vd_dlm3 d_dlm3 0 pwl(
+ 0 0 4e-07 0 5e-07 0.05 2.91e-05 0.05 2.92e-05 0)
Xdlm3 g_dlm3 d_dlm3 0 0 fefet_c16 x0_1=-0.383892713 x0_2=0.494920498 x0_3=0.765928312 x0_4=0.877353323 x0_5=0.931338721 x0_6=0.960153359
+ x0_7=0.97646694 x0_8=0.986063857 x0_9=0.991824233 x0_10=0.995315188 x0_11=0.997419993 x0_12=0.998666362
+ x0_13=0.999377451 x0_14=0.999756435 x0_15=0.999933867 x0_16=0.999954144
.ic v(xdlm3.m)=0.359265981
Vg_dhp3 g_dhp3 0 pwl(
+ 0 0 1e-06 0 2e-06 -0.2 2.2e-06 -0.18 2.4e-06 -0.16 2.6e-06 -0.14
+ 2.8e-06 -0.12 3e-06 -0.1 3.2e-06 -0.08 3.4e-06 -0.06 3.6e-06 -0.04 3.8e-06 -0.02
+ 4e-06 0 4.2e-06 0.02 4.4e-06 0.04 4.6e-06 0.06 4.8e-06 0.08 5e-06 0.1
+ 5.2e-06 0.12 5.4e-06 0.14 5.6e-06 0.16 5.8e-06 0.18 6e-06 0.2 6.2e-06 0.22
+ 6.4e-06 0.24 6.6e-06 0.26 6.8e-06 0.28 7e-06 0.3 7.2e-06 0.32 7.4e-06 0.34
+ 7.6e-06 0.36 7.8e-06 0.38 8e-06 0.4 8.2e-06 0.42 8.4e-06 0.44 8.6e-06 0.46
+ 8.8e-06 0.48 9e-06 0.5 9.2e-06 0.52 9.4e-06 0.54 9.6e-06 0.56 9.8e-06 0.58
+ 1e-05 0.6 1.02e-05 0.62 1.04e-05 0.64 1.06e-05 0.66 1.08e-05 0.68 1.1e-05 0.7
+ 1.12e-05 0.72 1.14e-05 0.74 1.16e-05 0.76 1.18e-05 0.78 1.2e-05 0.8 1.22e-05 0.82
+ 1.24e-05 0.84 1.26e-05 0.86 1.28e-05 0.88 1.3e-05 0.9 1.32e-05 0.92 1.34e-05 0.94
+ 1.36e-05 0.96 1.38e-05 0.98 1.4e-05 1 1.42e-05 1.02 1.44e-05 1.04 1.46e-05 1.06
+ 1.48e-05 1.08 1.5e-05 1.1 1.52e-05 1.12 1.54e-05 1.14 1.56e-05 1.16 1.58e-05 1.18
+ 1.6e-05 1.2 1.62e-05 1.22 1.64e-05 1.24 1.66e-05 1.26 1.68e-05 1.28 1.7e-05 1.3
+ 1.72e-05 1.32 1.74e-05 1.34 1.76e-05 1.36 1.78e-05 1.38 1.8e-05 1.4 1.82e-05 1.42
+ 1.84e-05 1.44 1.86e-05 1.46 1.88e-05 1.48 1.9e-05 1.5 1.92e-05 1.52 1.94e-05 1.54
+ 1.96e-05 1.56 1.98e-05 1.58 2e-05 1.6 2.02e-05 1.62 2.04e-05 1.64 2.06e-05 1.66
+ 2.08e-05 1.68 2.1e-05 1.7 2.12e-05 1.72 2.14e-05 1.74 2.16e-05 1.76 2.18e-05 1.78
+ 2.2e-05 1.8 2.22e-05 1.82 2.24e-05 1.84 2.26e-05 1.86 2.28e-05 1.88 2.3e-05 1.9
+ 2.32e-05 1.92 2.34e-05 1.94 2.36e-05 1.96 2.38e-05 1.98 2.4e-05 2 2.42e-05 2.02
+ 2.44e-05 2.04 2.46e-05 2.06 2.48e-05 2.08 2.5e-05 2.1 2.52e-05 2.12 2.54e-05 2.14
+ 2.56e-05 2.16 2.58e-05 2.18 2.6e-05 2.2 2.62e-05 2.22 2.64e-05 2.24 2.66e-05 2.26
+ 2.68e-05 2.28 2.7e-05 2.3 2.72e-05 2.32 2.74e-05 2.34 2.76e-05 2.36 2.78e-05 2.38
+ 2.8e-05 2.4 2.9e-05 0)
Vd_dhp3 d_dhp3 0 pwl(
+ 0 0 4e-07 0 5e-07 0.05 2.91e-05 0.05 2.92e-05 0)
Xdhp3 g_dhp3 d_dhp3 0 0 fefet_c16 x0_1=-1 x0_2=-1 x0_3=-1 x0_4=-1 x0_5=-1 x0_6=-1
+ x0_7=-1 x0_8=-1 x0_9=-1 x0_10=-1 x0_11=-1 x0_12=-1
+ x0_13=-1 x0_14=-1 x0_15=-1 x0_16=-1
.ic v(xdhp3.m)=-0.277157367
Vg_dhm3 g_dhm3 0 pwl(
+ 0 0 1e-06 0 2e-06 -0.2 2.2e-06 -0.18 2.4e-06 -0.16 2.6e-06 -0.14
+ 2.8e-06 -0.12 3e-06 -0.1 3.2e-06 -0.08 3.4e-06 -0.06 3.6e-06 -0.04 3.8e-06 -0.02
+ 4e-06 0 4.2e-06 0.02 4.4e-06 0.04 4.6e-06 0.06 4.8e-06 0.08 5e-06 0.1
+ 5.2e-06 0.12 5.4e-06 0.14 5.6e-06 0.16 5.8e-06 0.18 6e-06 0.2 6.2e-06 0.22
+ 6.4e-06 0.24 6.6e-06 0.26 6.8e-06 0.28 7e-06 0.3 7.2e-06 0.32 7.4e-06 0.34
+ 7.6e-06 0.36 7.8e-06 0.38 8e-06 0.4 8.2e-06 0.42 8.4e-06 0.44 8.6e-06 0.46
+ 8.8e-06 0.48 9e-06 0.5 9.2e-06 0.52 9.4e-06 0.54 9.6e-06 0.56 9.8e-06 0.58
+ 1e-05 0.6 1.02e-05 0.62 1.04e-05 0.64 1.06e-05 0.66 1.08e-05 0.68 1.1e-05 0.7
+ 1.12e-05 0.72 1.14e-05 0.74 1.16e-05 0.76 1.18e-05 0.78 1.2e-05 0.8 1.22e-05 0.82
+ 1.24e-05 0.84 1.26e-05 0.86 1.28e-05 0.88 1.3e-05 0.9 1.32e-05 0.92 1.34e-05 0.94
+ 1.36e-05 0.96 1.38e-05 0.98 1.4e-05 1 1.42e-05 1.02 1.44e-05 1.04 1.46e-05 1.06
+ 1.48e-05 1.08 1.5e-05 1.1 1.52e-05 1.12 1.54e-05 1.14 1.56e-05 1.16 1.58e-05 1.18
+ 1.6e-05 1.2 1.62e-05 1.22 1.64e-05 1.24 1.66e-05 1.26 1.68e-05 1.28 1.7e-05 1.3
+ 1.72e-05 1.32 1.74e-05 1.34 1.76e-05 1.36 1.78e-05 1.38 1.8e-05 1.4 1.82e-05 1.42
+ 1.84e-05 1.44 1.86e-05 1.46 1.88e-05 1.48 1.9e-05 1.5 1.92e-05 1.52 1.94e-05 1.54
+ 1.96e-05 1.56 1.98e-05 1.58 2e-05 1.6 2.02e-05 1.62 2.04e-05 1.64 2.06e-05 1.66
+ 2.08e-05 1.68 2.1e-05 1.7 2.12e-05 1.72 2.14e-05 1.74 2.16e-05 1.76 2.18e-05 1.78
+ 2.2e-05 1.8 2.22e-05 1.82 2.24e-05 1.84 2.26e-05 1.86 2.28e-05 1.88 2.3e-05 1.9
+ 2.32e-05 1.92 2.34e-05 1.94 2.36e-05 1.96 2.38e-05 1.98 2.4e-05 2 2.42e-05 2.02
+ 2.44e-05 2.04 2.46e-05 2.06 2.48e-05 2.08 2.5e-05 2.1 2.52e-05 2.12 2.54e-05 2.14
+ 2.56e-05 2.16 2.58e-05 2.18 2.6e-05 2.2 2.62e-05 2.22 2.64e-05 2.24 2.66e-05 2.26
+ 2.68e-05 2.28 2.7e-05 2.3 2.72e-05 2.32 2.74e-05 2.34 2.76e-05 2.36 2.78e-05 2.38
+ 2.8e-05 2.4 2.9e-05 0)
Vd_dhm3 d_dhm3 0 pwl(
+ 0 0 4e-07 0 5e-07 0.05 2.91e-05 0.05 2.92e-05 0)
Xdhm3 g_dhm3 d_dhm3 0 0 fefet_c16 x0_1=-1 x0_2=-1 x0_3=-1 x0_4=-1 x0_5=-1 x0_6=-1
+ x0_7=-1 x0_8=-1 x0_9=-1 x0_10=-1 x0_11=-1 x0_12=-1
+ x0_13=-1 x0_14=-1 x0_15=-1 x0_16=-1
.ic v(xdhm3.m)=-0.277154701
.control
set wr_singlescale
set wr_vecnames
tran 1n 3e-05 0 1.5e-07 uic
wrdata sim/out/t3a/t3a_read.csv v(g_r0c0l) i(vd_r0c0l) v(g_r0c0r) i(vd_r0c0r) v(g_r0c1l) i(vd_r0c1l) v(g_r0c1r) i(vd_r0c1r)
+ v(g_r0c2l) i(vd_r0c2l) v(g_r0c2r) i(vd_r0c2r) v(g_r0c3l) i(vd_r0c3l) v(g_r0c3r) i(vd_r0c3r)
+ v(g_r0c4l) i(vd_r0c4l) v(g_r0c4r) i(vd_r0c4r) v(g_r0c5l) i(vd_r0c5l) v(g_r0c5r) i(vd_r0c5r)
+ v(g_r0c6l) i(vd_r0c6l) v(g_r0c6r) i(vd_r0c6r) v(g_r0c7l) i(vd_r0c7l) v(g_r0c7r) i(vd_r0c7r)
+ v(g_r1c0l) i(vd_r1c0l) v(g_r1c0r) i(vd_r1c0r) v(g_r1c1l) i(vd_r1c1l) v(g_r1c1r) i(vd_r1c1r)
+ v(g_r1c2l) i(vd_r1c2l) v(g_r1c2r) i(vd_r1c2r) v(g_r1c3l) i(vd_r1c3l) v(g_r1c3r) i(vd_r1c3r)
+ v(g_r1c4l) i(vd_r1c4l) v(g_r1c4r) i(vd_r1c4r) v(g_r1c5l) i(vd_r1c5l) v(g_r1c5r) i(vd_r1c5r)
+ v(g_r1c6l) i(vd_r1c6l) v(g_r1c6r) i(vd_r1c6r) v(g_r1c7l) i(vd_r1c7l) v(g_r1c7r) i(vd_r1c7r)
+ v(g_dlp) i(vd_dlp) v(g_dlm) i(vd_dlm) v(g_dhp) i(vd_dhp) v(g_dhm) i(vd_dhm)
+ v(g_dl0) i(vd_dl0) v(g_dh0) i(vd_dh0) v(g_dlp3) i(vd_dlp3) v(g_dlm3) i(vd_dlm3)
+ v(g_dhp3) i(vd_dhp3) v(g_dhm3) i(vd_dhm3)
.endc
.end
