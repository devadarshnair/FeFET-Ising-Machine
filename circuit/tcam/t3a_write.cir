* t3a_write.cir -- generated by circuit/tcam/make_tcam.py write
* Test 3a: write one 8-cell word (row 0) with the two-phase scheme while a second word (row 1)
* shares the same gate columns and is inhibited with V_W/2 on its ML, ScL and well.
* Phase 1 (1.5-11.51 us): every gate line at -4.0 V (row 0 -> high V_th); row 1 lines at -2.0 V.
* Phase 2 (13.5-23.52 us): gate lines of the FeFETs that must be low V_th at +4.0 V,
* the rest at 0 V; row 1 lines at +2.0 V. Row 0 ML, ScL and well stay at 0 V (Ni 2019).
* Row 0 starts as 0100X011 and is written to 1011X100; row 1 holds 01001X11. States saved 2 s after the write.
* The row-1 well, ML and ScL swing to -2 V: this needs a separate (triple) well per row.
.include ../../device/ngspice/fefet_preisach.lib
.include ../../models/mosfet/standin45_bsim4.lib
.include tcam_cells.lib
.options reltol=1e-3 abstol=1e-15 method=gear
Vinh inh 0 pwl(
+ 0 0 1e-06 0 1.05e-06 -2 1.196e-05 -2 1.201e-05 0 1.301e-05 0
+ 1.306e-05 2 2.397e-05 2 2.402e-05 0)
Vg0a g0a 0 pwl(
+ 0 0 1.5e-06 0 1.505e-06 -4 1.1505e-05 -4 1.151e-05 0)
Vg0b g0b 0 pwl(
+ 0 0 1.5e-06 0 1.505e-06 -4 1.1505e-05 -4 1.151e-05 0 1.351e-05 0
+ 1.3515e-05 4 2.3515e-05 4 2.352e-05 0)
Vg1a g1a 0 pwl(
+ 0 0 1.5e-06 0 1.505e-06 -4 1.1505e-05 -4 1.151e-05 0 1.351e-05 0
+ 1.3515e-05 4 2.3515e-05 4 2.352e-05 0)
Vg1b g1b 0 pwl(
+ 0 0 1.5e-06 0 1.505e-06 -4 1.1505e-05 -4 1.151e-05 0)
Vg2a g2a 0 pwl(
+ 0 0 1.5e-06 0 1.505e-06 -4 1.1505e-05 -4 1.151e-05 0)
Vg2b g2b 0 pwl(
+ 0 0 1.5e-06 0 1.505e-06 -4 1.1505e-05 -4 1.151e-05 0 1.351e-05 0
+ 1.3515e-05 4 2.3515e-05 4 2.352e-05 0)
Vg3a g3a 0 pwl(
+ 0 0 1.5e-06 0 1.505e-06 -4 1.1505e-05 -4 1.151e-05 0)
Vg3b g3b 0 pwl(
+ 0 0 1.5e-06 0 1.505e-06 -4 1.1505e-05 -4 1.151e-05 0 1.351e-05 0
+ 1.3515e-05 4 2.3515e-05 4 2.352e-05 0)
Vg4a g4a 0 pwl(
+ 0 0 1.5e-06 0 1.505e-06 -4 1.1505e-05 -4 1.151e-05 0)
Vg4b g4b 0 pwl(
+ 0 0 1.5e-06 0 1.505e-06 -4 1.1505e-05 -4 1.151e-05 0)
Vg5a g5a 0 pwl(
+ 0 0 1.5e-06 0 1.505e-06 -4 1.1505e-05 -4 1.151e-05 0)
Vg5b g5b 0 pwl(
+ 0 0 1.5e-06 0 1.505e-06 -4 1.1505e-05 -4 1.151e-05 0 1.351e-05 0
+ 1.3515e-05 4 2.3515e-05 4 2.352e-05 0)
Vg6a g6a 0 pwl(
+ 0 0 1.5e-06 0 1.505e-06 -4 1.1505e-05 -4 1.151e-05 0 1.351e-05 0
+ 1.3515e-05 4 2.3515e-05 4 2.352e-05 0)
Vg6b g6b 0 pwl(
+ 0 0 1.5e-06 0 1.505e-06 -4 1.1505e-05 -4 1.151e-05 0)
Vg7a g7a 0 pwl(
+ 0 0 1.5e-06 0 1.505e-06 -4 1.1505e-05 -4 1.151e-05 0 1.351e-05 0
+ 1.3515e-05 4 2.3515e-05 4 2.352e-05 0)
Vg7b g7b 0 pwl(
+ 0 0 1.5e-06 0 1.505e-06 -4 1.1505e-05 -4 1.151e-05 0)
Xc0_0 g0a g0b 0 0 0 tcam2f dvgl=0 dvgr=0 xl1=1 xl2=1 xl3=1 xl4=1 xl5=1 xl6=1
+ xl7=1 xl8=1 xl9=1 xl10=1 xl11=1 xl12=1 xl13=1 xl14=0.999999988
+ xl15=1.00000021 xl16=0.999959662 xr1=-1 xr2=-1 xr3=-1 xr4=-1 xr5=-1 xr6=-1
+ xr7=-1 xr8=-1 xr9=-1 xr10=-1 xr11=-1 xr12=-1 xr13=-1 xr14=-1
+ xr15=-1 xr16=-1
.ic v(xc0_0.xl.m)=0.424804359 v(xc0_0.xr.m)=-0.277154442
Xc0_1 g1a g1b 0 0 0 tcam2f dvgl=0 dvgr=0 xl1=-1 xl2=-1 xl3=-1 xl4=-1 xl5=-1 xl6=-1
+ xl7=-1 xl8=-1 xl9=-1 xl10=-1 xl11=-1 xl12=-1 xl13=-1 xl14=-1
+ xl15=-1 xl16=-1 xr1=1 xr2=1 xr3=1 xr4=1 xr5=1 xr6=1
+ xr7=1 xr8=1 xr9=1 xr10=1 xr11=1 xr12=1 xr13=1 xr14=0.999999988
+ xr15=1.00000021 xr16=0.999959662
.ic v(xc0_1.xl.m)=-0.277154442 v(xc0_1.xr.m)=0.424804359
Xc0_2 g2a g2b 0 0 0 tcam2f dvgl=0 dvgr=0 xl1=1 xl2=1 xl3=1 xl4=1 xl5=1 xl6=1
+ xl7=1 xl8=1 xl9=1 xl10=1 xl11=1 xl12=1 xl13=1 xl14=0.999999988
+ xl15=1.00000021 xl16=0.999959662 xr1=-1 xr2=-1 xr3=-1 xr4=-1 xr5=-1 xr6=-1
+ xr7=-1 xr8=-1 xr9=-1 xr10=-1 xr11=-1 xr12=-1 xr13=-1 xr14=-1
+ xr15=-1 xr16=-1
.ic v(xc0_2.xl.m)=0.424804359 v(xc0_2.xr.m)=-0.277154442
Xc0_3 g3a g3b 0 0 0 tcam2f dvgl=0 dvgr=0 xl1=1 xl2=1 xl3=1 xl4=1 xl5=1 xl6=1
+ xl7=1 xl8=1 xl9=1 xl10=1 xl11=1 xl12=1 xl13=1 xl14=0.999999988
+ xl15=1.00000021 xl16=0.999959662 xr1=-1 xr2=-1 xr3=-1 xr4=-1 xr5=-1 xr6=-1
+ xr7=-1 xr8=-1 xr9=-1 xr10=-1 xr11=-1 xr12=-1 xr13=-1 xr14=-1
+ xr15=-1 xr16=-1
.ic v(xc0_3.xl.m)=0.424804359 v(xc0_3.xr.m)=-0.277154442
Xc0_4 g4a g4b 0 0 0 tcam2f dvgl=0 dvgr=0 xl1=-1 xl2=-1 xl3=-1 xl4=-1 xl5=-1 xl6=-1
+ xl7=-1 xl8=-1 xl9=-1 xl10=-1 xl11=-1 xl12=-1 xl13=-1 xl14=-1
+ xl15=-1 xl16=-1 xr1=-1 xr2=-1 xr3=-1 xr4=-1 xr5=-1 xr6=-1
+ xr7=-1 xr8=-1 xr9=-1 xr10=-1 xr11=-1 xr12=-1 xr13=-1 xr14=-1
+ xr15=-1 xr16=-1
.ic v(xc0_4.xl.m)=-0.277154442 v(xc0_4.xr.m)=-0.277154442
Xc0_5 g5a g5b 0 0 0 tcam2f dvgl=0 dvgr=0 xl1=1 xl2=1 xl3=1 xl4=1 xl5=1 xl6=1
+ xl7=1 xl8=1 xl9=1 xl10=1 xl11=1 xl12=1 xl13=1 xl14=0.999999988
+ xl15=1.00000021 xl16=0.999959662 xr1=-1 xr2=-1 xr3=-1 xr4=-1 xr5=-1 xr6=-1
+ xr7=-1 xr8=-1 xr9=-1 xr10=-1 xr11=-1 xr12=-1 xr13=-1 xr14=-1
+ xr15=-1 xr16=-1
.ic v(xc0_5.xl.m)=0.424804359 v(xc0_5.xr.m)=-0.277154442
Xc0_6 g6a g6b 0 0 0 tcam2f dvgl=0 dvgr=0 xl1=-1 xl2=-1 xl3=-1 xl4=-1 xl5=-1 xl6=-1
+ xl7=-1 xl8=-1 xl9=-1 xl10=-1 xl11=-1 xl12=-1 xl13=-1 xl14=-1
+ xl15=-1 xl16=-1 xr1=1 xr2=1 xr3=1 xr4=1 xr5=1 xr6=1
+ xr7=1 xr8=1 xr9=1 xr10=1 xr11=1 xr12=1 xr13=1 xr14=0.999999988
+ xr15=1.00000021 xr16=0.999959662
.ic v(xc0_6.xl.m)=-0.277154442 v(xc0_6.xr.m)=0.424804359
Xc0_7 g7a g7b 0 0 0 tcam2f dvgl=0 dvgr=0 xl1=-1 xl2=-1 xl3=-1 xl4=-1 xl5=-1 xl6=-1
+ xl7=-1 xl8=-1 xl9=-1 xl10=-1 xl11=-1 xl12=-1 xl13=-1 xl14=-1
+ xl15=-1 xl16=-1 xr1=1 xr2=1 xr3=1 xr4=1 xr5=1 xr6=1
+ xr7=1 xr8=1 xr9=1 xr10=1 xr11=1 xr12=1 xr13=1 xr14=0.999999988
+ xr15=1.00000021 xr16=0.999959662
.ic v(xc0_7.xl.m)=-0.277154442 v(xc0_7.xr.m)=0.424804359
Xc1_0 g0a g0b inh inh inh tcam2f dvgl=0 dvgr=0 xl1=1 xl2=1 xl3=1 xl4=1 xl5=1 xl6=1
+ xl7=1 xl8=1 xl9=1 xl10=1 xl11=1 xl12=1 xl13=1 xl14=0.999999988
+ xl15=1.00000021 xl16=0.999959662 xr1=-1 xr2=-1 xr3=-1 xr4=-1 xr5=-1 xr6=-1
+ xr7=-1 xr8=-1 xr9=-1 xr10=-1 xr11=-1 xr12=-1 xr13=-1 xr14=-1
+ xr15=-1 xr16=-1
.ic v(xc1_0.xl.m)=0.424804359 v(xc1_0.xr.m)=-0.277154442
Xc1_1 g1a g1b inh inh inh tcam2f dvgl=0 dvgr=0 xl1=-1 xl2=-1 xl3=-1 xl4=-1 xl5=-1 xl6=-1
+ xl7=-1 xl8=-1 xl9=-1 xl10=-1 xl11=-1 xl12=-1 xl13=-1 xl14=-1
+ xl15=-1 xl16=-1 xr1=1 xr2=1 xr3=1 xr4=1 xr5=1 xr6=1
+ xr7=1 xr8=1 xr9=1 xr10=1 xr11=1 xr12=1 xr13=1 xr14=0.999999988
+ xr15=1.00000021 xr16=0.999959662
.ic v(xc1_1.xl.m)=-0.277154442 v(xc1_1.xr.m)=0.424804359
Xc1_2 g2a g2b inh inh inh tcam2f dvgl=0 dvgr=0 xl1=1 xl2=1 xl3=1 xl4=1 xl5=1 xl6=1
+ xl7=1 xl8=1 xl9=1 xl10=1 xl11=1 xl12=1 xl13=1 xl14=0.999999988
+ xl15=1.00000021 xl16=0.999959662 xr1=-1 xr2=-1 xr3=-1 xr4=-1 xr5=-1 xr6=-1
+ xr7=-1 xr8=-1 xr9=-1 xr10=-1 xr11=-1 xr12=-1 xr13=-1 xr14=-1
+ xr15=-1 xr16=-1
.ic v(xc1_2.xl.m)=0.424804359 v(xc1_2.xr.m)=-0.277154442
Xc1_3 g3a g3b inh inh inh tcam2f dvgl=0 dvgr=0 xl1=1 xl2=1 xl3=1 xl4=1 xl5=1 xl6=1
+ xl7=1 xl8=1 xl9=1 xl10=1 xl11=1 xl12=1 xl13=1 xl14=0.999999988
+ xl15=1.00000021 xl16=0.999959662 xr1=-1 xr2=-1 xr3=-1 xr4=-1 xr5=-1 xr6=-1
+ xr7=-1 xr8=-1 xr9=-1 xr10=-1 xr11=-1 xr12=-1 xr13=-1 xr14=-1
+ xr15=-1 xr16=-1
.ic v(xc1_3.xl.m)=0.424804359 v(xc1_3.xr.m)=-0.277154442
Xc1_4 g4a g4b inh inh inh tcam2f dvgl=0 dvgr=0 xl1=-1 xl2=-1 xl3=-1 xl4=-1 xl5=-1 xl6=-1
+ xl7=-1 xl8=-1 xl9=-1 xl10=-1 xl11=-1 xl12=-1 xl13=-1 xl14=-1
+ xl15=-1 xl16=-1 xr1=1 xr2=1 xr3=1 xr4=1 xr5=1 xr6=1
+ xr7=1 xr8=1 xr9=1 xr10=1 xr11=1 xr12=1 xr13=1 xr14=0.999999988
+ xr15=1.00000021 xr16=0.999959662
.ic v(xc1_4.xl.m)=-0.277154442 v(xc1_4.xr.m)=0.424804359
Xc1_5 g5a g5b inh inh inh tcam2f dvgl=0 dvgr=0 xl1=-1 xl2=-1 xl3=-1 xl4=-1 xl5=-1 xl6=-1
+ xl7=-1 xl8=-1 xl9=-1 xl10=-1 xl11=-1 xl12=-1 xl13=-1 xl14=-1
+ xl15=-1 xl16=-1 xr1=-1 xr2=-1 xr3=-1 xr4=-1 xr5=-1 xr6=-1
+ xr7=-1 xr8=-1 xr9=-1 xr10=-1 xr11=-1 xr12=-1 xr13=-1 xr14=-1
+ xr15=-1 xr16=-1
.ic v(xc1_5.xl.m)=-0.277154442 v(xc1_5.xr.m)=-0.277154442
Xc1_6 g6a g6b inh inh inh tcam2f dvgl=0 dvgr=0 xl1=-1 xl2=-1 xl3=-1 xl4=-1 xl5=-1 xl6=-1
+ xl7=-1 xl8=-1 xl9=-1 xl10=-1 xl11=-1 xl12=-1 xl13=-1 xl14=-1
+ xl15=-1 xl16=-1 xr1=1 xr2=1 xr3=1 xr4=1 xr5=1 xr6=1
+ xr7=1 xr8=1 xr9=1 xr10=1 xr11=1 xr12=1 xr13=1 xr14=0.999999988
+ xr15=1.00000021 xr16=0.999959662
.ic v(xc1_6.xl.m)=-0.277154442 v(xc1_6.xr.m)=0.424804359
Xc1_7 g7a g7b inh inh inh tcam2f dvgl=0 dvgr=0 xl1=-1 xl2=-1 xl3=-1 xl4=-1 xl5=-1 xl6=-1
+ xl7=-1 xl8=-1 xl9=-1 xl10=-1 xl11=-1 xl12=-1 xl13=-1 xl14=-1
+ xl15=-1 xl16=-1 xr1=1 xr2=1 xr3=1 xr4=1 xr5=1 xr6=1
+ xr7=1 xr8=1 xr9=1 xr10=1 xr11=1 xr12=1 xr13=1 xr14=0.999999988
+ xr15=1.00000021 xr16=0.999959662
.ic v(xc1_7.xl.m)=-0.277154442 v(xc1_7.xr.m)=0.424804359
.control
set wr_singlescale
set wr_vecnames
tran 1n 2.00002352 0 0.0100001 uic
wrdata sim/out/t3a/t3a_write.csv v(xc0_0.xl.xfe.x1) v(xc0_0.xl.xfe.x2) v(xc0_0.xl.xfe.x3) v(xc0_0.xl.xfe.x4) v(xc0_0.xl.xfe.x5) v(xc0_0.xl.xfe.x6) v(xc0_0.xl.xfe.x7) v(xc0_0.xl.xfe.x8)
+ v(xc0_0.xl.xfe.x9) v(xc0_0.xl.xfe.x10) v(xc0_0.xl.xfe.x11) v(xc0_0.xl.xfe.x12) v(xc0_0.xl.xfe.x13) v(xc0_0.xl.xfe.x14) v(xc0_0.xl.xfe.x15) v(xc0_0.xl.xfe.x16)
+ v(xc0_0.xl.m) v(xc0_0.xr.xfe.x1) v(xc0_0.xr.xfe.x2) v(xc0_0.xr.xfe.x3) v(xc0_0.xr.xfe.x4) v(xc0_0.xr.xfe.x5) v(xc0_0.xr.xfe.x6) v(xc0_0.xr.xfe.x7)
+ v(xc0_0.xr.xfe.x8) v(xc0_0.xr.xfe.x9) v(xc0_0.xr.xfe.x10) v(xc0_0.xr.xfe.x11) v(xc0_0.xr.xfe.x12) v(xc0_0.xr.xfe.x13) v(xc0_0.xr.xfe.x14) v(xc0_0.xr.xfe.x15)
+ v(xc0_0.xr.xfe.x16) v(xc0_0.xr.m) v(xc0_1.xl.xfe.x1) v(xc0_1.xl.xfe.x2) v(xc0_1.xl.xfe.x3) v(xc0_1.xl.xfe.x4) v(xc0_1.xl.xfe.x5) v(xc0_1.xl.xfe.x6)
+ v(xc0_1.xl.xfe.x7) v(xc0_1.xl.xfe.x8) v(xc0_1.xl.xfe.x9) v(xc0_1.xl.xfe.x10) v(xc0_1.xl.xfe.x11) v(xc0_1.xl.xfe.x12) v(xc0_1.xl.xfe.x13) v(xc0_1.xl.xfe.x14)
+ v(xc0_1.xl.xfe.x15) v(xc0_1.xl.xfe.x16) v(xc0_1.xl.m) v(xc0_1.xr.xfe.x1) v(xc0_1.xr.xfe.x2) v(xc0_1.xr.xfe.x3) v(xc0_1.xr.xfe.x4) v(xc0_1.xr.xfe.x5)
+ v(xc0_1.xr.xfe.x6) v(xc0_1.xr.xfe.x7) v(xc0_1.xr.xfe.x8) v(xc0_1.xr.xfe.x9) v(xc0_1.xr.xfe.x10) v(xc0_1.xr.xfe.x11) v(xc0_1.xr.xfe.x12) v(xc0_1.xr.xfe.x13)
+ v(xc0_1.xr.xfe.x14) v(xc0_1.xr.xfe.x15) v(xc0_1.xr.xfe.x16) v(xc0_1.xr.m) v(xc0_2.xl.xfe.x1) v(xc0_2.xl.xfe.x2) v(xc0_2.xl.xfe.x3) v(xc0_2.xl.xfe.x4)
+ v(xc0_2.xl.xfe.x5) v(xc0_2.xl.xfe.x6) v(xc0_2.xl.xfe.x7) v(xc0_2.xl.xfe.x8) v(xc0_2.xl.xfe.x9) v(xc0_2.xl.xfe.x10) v(xc0_2.xl.xfe.x11) v(xc0_2.xl.xfe.x12)
+ v(xc0_2.xl.xfe.x13) v(xc0_2.xl.xfe.x14) v(xc0_2.xl.xfe.x15) v(xc0_2.xl.xfe.x16) v(xc0_2.xl.m) v(xc0_2.xr.xfe.x1) v(xc0_2.xr.xfe.x2) v(xc0_2.xr.xfe.x3)
+ v(xc0_2.xr.xfe.x4) v(xc0_2.xr.xfe.x5) v(xc0_2.xr.xfe.x6) v(xc0_2.xr.xfe.x7) v(xc0_2.xr.xfe.x8) v(xc0_2.xr.xfe.x9) v(xc0_2.xr.xfe.x10) v(xc0_2.xr.xfe.x11)
+ v(xc0_2.xr.xfe.x12) v(xc0_2.xr.xfe.x13) v(xc0_2.xr.xfe.x14) v(xc0_2.xr.xfe.x15) v(xc0_2.xr.xfe.x16) v(xc0_2.xr.m) v(xc0_3.xl.xfe.x1) v(xc0_3.xl.xfe.x2)
+ v(xc0_3.xl.xfe.x3) v(xc0_3.xl.xfe.x4) v(xc0_3.xl.xfe.x5) v(xc0_3.xl.xfe.x6) v(xc0_3.xl.xfe.x7) v(xc0_3.xl.xfe.x8) v(xc0_3.xl.xfe.x9) v(xc0_3.xl.xfe.x10)
+ v(xc0_3.xl.xfe.x11) v(xc0_3.xl.xfe.x12) v(xc0_3.xl.xfe.x13) v(xc0_3.xl.xfe.x14) v(xc0_3.xl.xfe.x15) v(xc0_3.xl.xfe.x16) v(xc0_3.xl.m) v(xc0_3.xr.xfe.x1)
+ v(xc0_3.xr.xfe.x2) v(xc0_3.xr.xfe.x3) v(xc0_3.xr.xfe.x4) v(xc0_3.xr.xfe.x5) v(xc0_3.xr.xfe.x6) v(xc0_3.xr.xfe.x7) v(xc0_3.xr.xfe.x8) v(xc0_3.xr.xfe.x9)
+ v(xc0_3.xr.xfe.x10) v(xc0_3.xr.xfe.x11) v(xc0_3.xr.xfe.x12) v(xc0_3.xr.xfe.x13) v(xc0_3.xr.xfe.x14) v(xc0_3.xr.xfe.x15) v(xc0_3.xr.xfe.x16) v(xc0_3.xr.m)
+ v(xc0_4.xl.xfe.x1) v(xc0_4.xl.xfe.x2) v(xc0_4.xl.xfe.x3) v(xc0_4.xl.xfe.x4) v(xc0_4.xl.xfe.x5) v(xc0_4.xl.xfe.x6) v(xc0_4.xl.xfe.x7) v(xc0_4.xl.xfe.x8)
+ v(xc0_4.xl.xfe.x9) v(xc0_4.xl.xfe.x10) v(xc0_4.xl.xfe.x11) v(xc0_4.xl.xfe.x12) v(xc0_4.xl.xfe.x13) v(xc0_4.xl.xfe.x14) v(xc0_4.xl.xfe.x15) v(xc0_4.xl.xfe.x16)
+ v(xc0_4.xl.m) v(xc0_4.xr.xfe.x1) v(xc0_4.xr.xfe.x2) v(xc0_4.xr.xfe.x3) v(xc0_4.xr.xfe.x4) v(xc0_4.xr.xfe.x5) v(xc0_4.xr.xfe.x6) v(xc0_4.xr.xfe.x7)
+ v(xc0_4.xr.xfe.x8) v(xc0_4.xr.xfe.x9) v(xc0_4.xr.xfe.x10) v(xc0_4.xr.xfe.x11) v(xc0_4.xr.xfe.x12) v(xc0_4.xr.xfe.x13) v(xc0_4.xr.xfe.x14) v(xc0_4.xr.xfe.x15)
+ v(xc0_4.xr.xfe.x16) v(xc0_4.xr.m) v(xc0_5.xl.xfe.x1) v(xc0_5.xl.xfe.x2) v(xc0_5.xl.xfe.x3) v(xc0_5.xl.xfe.x4) v(xc0_5.xl.xfe.x5) v(xc0_5.xl.xfe.x6)
+ v(xc0_5.xl.xfe.x7) v(xc0_5.xl.xfe.x8) v(xc0_5.xl.xfe.x9) v(xc0_5.xl.xfe.x10) v(xc0_5.xl.xfe.x11) v(xc0_5.xl.xfe.x12) v(xc0_5.xl.xfe.x13) v(xc0_5.xl.xfe.x14)
+ v(xc0_5.xl.xfe.x15) v(xc0_5.xl.xfe.x16) v(xc0_5.xl.m) v(xc0_5.xr.xfe.x1) v(xc0_5.xr.xfe.x2) v(xc0_5.xr.xfe.x3) v(xc0_5.xr.xfe.x4) v(xc0_5.xr.xfe.x5)
+ v(xc0_5.xr.xfe.x6) v(xc0_5.xr.xfe.x7) v(xc0_5.xr.xfe.x8) v(xc0_5.xr.xfe.x9) v(xc0_5.xr.xfe.x10) v(xc0_5.xr.xfe.x11) v(xc0_5.xr.xfe.x12) v(xc0_5.xr.xfe.x13)
+ v(xc0_5.xr.xfe.x14) v(xc0_5.xr.xfe.x15) v(xc0_5.xr.xfe.x16) v(xc0_5.xr.m) v(xc0_6.xl.xfe.x1) v(xc0_6.xl.xfe.x2) v(xc0_6.xl.xfe.x3) v(xc0_6.xl.xfe.x4)
+ v(xc0_6.xl.xfe.x5) v(xc0_6.xl.xfe.x6) v(xc0_6.xl.xfe.x7) v(xc0_6.xl.xfe.x8) v(xc0_6.xl.xfe.x9) v(xc0_6.xl.xfe.x10) v(xc0_6.xl.xfe.x11) v(xc0_6.xl.xfe.x12)
+ v(xc0_6.xl.xfe.x13) v(xc0_6.xl.xfe.x14) v(xc0_6.xl.xfe.x15) v(xc0_6.xl.xfe.x16) v(xc0_6.xl.m) v(xc0_6.xr.xfe.x1) v(xc0_6.xr.xfe.x2) v(xc0_6.xr.xfe.x3)
+ v(xc0_6.xr.xfe.x4) v(xc0_6.xr.xfe.x5) v(xc0_6.xr.xfe.x6) v(xc0_6.xr.xfe.x7) v(xc0_6.xr.xfe.x8) v(xc0_6.xr.xfe.x9) v(xc0_6.xr.xfe.x10) v(xc0_6.xr.xfe.x11)
+ v(xc0_6.xr.xfe.x12) v(xc0_6.xr.xfe.x13) v(xc0_6.xr.xfe.x14) v(xc0_6.xr.xfe.x15) v(xc0_6.xr.xfe.x16) v(xc0_6.xr.m) v(xc0_7.xl.xfe.x1) v(xc0_7.xl.xfe.x2)
+ v(xc0_7.xl.xfe.x3) v(xc0_7.xl.xfe.x4) v(xc0_7.xl.xfe.x5) v(xc0_7.xl.xfe.x6) v(xc0_7.xl.xfe.x7) v(xc0_7.xl.xfe.x8) v(xc0_7.xl.xfe.x9) v(xc0_7.xl.xfe.x10)
+ v(xc0_7.xl.xfe.x11) v(xc0_7.xl.xfe.x12) v(xc0_7.xl.xfe.x13) v(xc0_7.xl.xfe.x14) v(xc0_7.xl.xfe.x15) v(xc0_7.xl.xfe.x16) v(xc0_7.xl.m) v(xc0_7.xr.xfe.x1)
+ v(xc0_7.xr.xfe.x2) v(xc0_7.xr.xfe.x3) v(xc0_7.xr.xfe.x4) v(xc0_7.xr.xfe.x5) v(xc0_7.xr.xfe.x6) v(xc0_7.xr.xfe.x7) v(xc0_7.xr.xfe.x8) v(xc0_7.xr.xfe.x9)
+ v(xc0_7.xr.xfe.x10) v(xc0_7.xr.xfe.x11) v(xc0_7.xr.xfe.x12) v(xc0_7.xr.xfe.x13) v(xc0_7.xr.xfe.x14) v(xc0_7.xr.xfe.x15) v(xc0_7.xr.xfe.x16) v(xc0_7.xr.m)
+ v(xc1_0.xl.xfe.x1) v(xc1_0.xl.xfe.x2) v(xc1_0.xl.xfe.x3) v(xc1_0.xl.xfe.x4) v(xc1_0.xl.xfe.x5) v(xc1_0.xl.xfe.x6) v(xc1_0.xl.xfe.x7) v(xc1_0.xl.xfe.x8)
+ v(xc1_0.xl.xfe.x9) v(xc1_0.xl.xfe.x10) v(xc1_0.xl.xfe.x11) v(xc1_0.xl.xfe.x12) v(xc1_0.xl.xfe.x13) v(xc1_0.xl.xfe.x14) v(xc1_0.xl.xfe.x15) v(xc1_0.xl.xfe.x16)
+ v(xc1_0.xl.m) v(xc1_0.xr.xfe.x1) v(xc1_0.xr.xfe.x2) v(xc1_0.xr.xfe.x3) v(xc1_0.xr.xfe.x4) v(xc1_0.xr.xfe.x5) v(xc1_0.xr.xfe.x6) v(xc1_0.xr.xfe.x7)
+ v(xc1_0.xr.xfe.x8) v(xc1_0.xr.xfe.x9) v(xc1_0.xr.xfe.x10) v(xc1_0.xr.xfe.x11) v(xc1_0.xr.xfe.x12) v(xc1_0.xr.xfe.x13) v(xc1_0.xr.xfe.x14) v(xc1_0.xr.xfe.x15)
+ v(xc1_0.xr.xfe.x16) v(xc1_0.xr.m) v(xc1_1.xl.xfe.x1) v(xc1_1.xl.xfe.x2) v(xc1_1.xl.xfe.x3) v(xc1_1.xl.xfe.x4) v(xc1_1.xl.xfe.x5) v(xc1_1.xl.xfe.x6)
+ v(xc1_1.xl.xfe.x7) v(xc1_1.xl.xfe.x8) v(xc1_1.xl.xfe.x9) v(xc1_1.xl.xfe.x10) v(xc1_1.xl.xfe.x11) v(xc1_1.xl.xfe.x12) v(xc1_1.xl.xfe.x13) v(xc1_1.xl.xfe.x14)
+ v(xc1_1.xl.xfe.x15) v(xc1_1.xl.xfe.x16) v(xc1_1.xl.m) v(xc1_1.xr.xfe.x1) v(xc1_1.xr.xfe.x2) v(xc1_1.xr.xfe.x3) v(xc1_1.xr.xfe.x4) v(xc1_1.xr.xfe.x5)
+ v(xc1_1.xr.xfe.x6) v(xc1_1.xr.xfe.x7) v(xc1_1.xr.xfe.x8) v(xc1_1.xr.xfe.x9) v(xc1_1.xr.xfe.x10) v(xc1_1.xr.xfe.x11) v(xc1_1.xr.xfe.x12) v(xc1_1.xr.xfe.x13)
+ v(xc1_1.xr.xfe.x14) v(xc1_1.xr.xfe.x15) v(xc1_1.xr.xfe.x16) v(xc1_1.xr.m) v(xc1_2.xl.xfe.x1) v(xc1_2.xl.xfe.x2) v(xc1_2.xl.xfe.x3) v(xc1_2.xl.xfe.x4)
+ v(xc1_2.xl.xfe.x5) v(xc1_2.xl.xfe.x6) v(xc1_2.xl.xfe.x7) v(xc1_2.xl.xfe.x8) v(xc1_2.xl.xfe.x9) v(xc1_2.xl.xfe.x10) v(xc1_2.xl.xfe.x11) v(xc1_2.xl.xfe.x12)
+ v(xc1_2.xl.xfe.x13) v(xc1_2.xl.xfe.x14) v(xc1_2.xl.xfe.x15) v(xc1_2.xl.xfe.x16) v(xc1_2.xl.m) v(xc1_2.xr.xfe.x1) v(xc1_2.xr.xfe.x2) v(xc1_2.xr.xfe.x3)
+ v(xc1_2.xr.xfe.x4) v(xc1_2.xr.xfe.x5) v(xc1_2.xr.xfe.x6) v(xc1_2.xr.xfe.x7) v(xc1_2.xr.xfe.x8) v(xc1_2.xr.xfe.x9) v(xc1_2.xr.xfe.x10) v(xc1_2.xr.xfe.x11)
+ v(xc1_2.xr.xfe.x12) v(xc1_2.xr.xfe.x13) v(xc1_2.xr.xfe.x14) v(xc1_2.xr.xfe.x15) v(xc1_2.xr.xfe.x16) v(xc1_2.xr.m) v(xc1_3.xl.xfe.x1) v(xc1_3.xl.xfe.x2)
+ v(xc1_3.xl.xfe.x3) v(xc1_3.xl.xfe.x4) v(xc1_3.xl.xfe.x5) v(xc1_3.xl.xfe.x6) v(xc1_3.xl.xfe.x7) v(xc1_3.xl.xfe.x8) v(xc1_3.xl.xfe.x9) v(xc1_3.xl.xfe.x10)
+ v(xc1_3.xl.xfe.x11) v(xc1_3.xl.xfe.x12) v(xc1_3.xl.xfe.x13) v(xc1_3.xl.xfe.x14) v(xc1_3.xl.xfe.x15) v(xc1_3.xl.xfe.x16) v(xc1_3.xl.m) v(xc1_3.xr.xfe.x1)
+ v(xc1_3.xr.xfe.x2) v(xc1_3.xr.xfe.x3) v(xc1_3.xr.xfe.x4) v(xc1_3.xr.xfe.x5) v(xc1_3.xr.xfe.x6) v(xc1_3.xr.xfe.x7) v(xc1_3.xr.xfe.x8) v(xc1_3.xr.xfe.x9)
+ v(xc1_3.xr.xfe.x10) v(xc1_3.xr.xfe.x11) v(xc1_3.xr.xfe.x12) v(xc1_3.xr.xfe.x13) v(xc1_3.xr.xfe.x14) v(xc1_3.xr.xfe.x15) v(xc1_3.xr.xfe.x16) v(xc1_3.xr.m)
+ v(xc1_4.xl.xfe.x1) v(xc1_4.xl.xfe.x2) v(xc1_4.xl.xfe.x3) v(xc1_4.xl.xfe.x4) v(xc1_4.xl.xfe.x5) v(xc1_4.xl.xfe.x6) v(xc1_4.xl.xfe.x7) v(xc1_4.xl.xfe.x8)
+ v(xc1_4.xl.xfe.x9) v(xc1_4.xl.xfe.x10) v(xc1_4.xl.xfe.x11) v(xc1_4.xl.xfe.x12) v(xc1_4.xl.xfe.x13) v(xc1_4.xl.xfe.x14) v(xc1_4.xl.xfe.x15) v(xc1_4.xl.xfe.x16)
+ v(xc1_4.xl.m) v(xc1_4.xr.xfe.x1) v(xc1_4.xr.xfe.x2) v(xc1_4.xr.xfe.x3) v(xc1_4.xr.xfe.x4) v(xc1_4.xr.xfe.x5) v(xc1_4.xr.xfe.x6) v(xc1_4.xr.xfe.x7)
+ v(xc1_4.xr.xfe.x8) v(xc1_4.xr.xfe.x9) v(xc1_4.xr.xfe.x10) v(xc1_4.xr.xfe.x11) v(xc1_4.xr.xfe.x12) v(xc1_4.xr.xfe.x13) v(xc1_4.xr.xfe.x14) v(xc1_4.xr.xfe.x15)
+ v(xc1_4.xr.xfe.x16) v(xc1_4.xr.m) v(xc1_5.xl.xfe.x1) v(xc1_5.xl.xfe.x2) v(xc1_5.xl.xfe.x3) v(xc1_5.xl.xfe.x4) v(xc1_5.xl.xfe.x5) v(xc1_5.xl.xfe.x6)
+ v(xc1_5.xl.xfe.x7) v(xc1_5.xl.xfe.x8) v(xc1_5.xl.xfe.x9) v(xc1_5.xl.xfe.x10) v(xc1_5.xl.xfe.x11) v(xc1_5.xl.xfe.x12) v(xc1_5.xl.xfe.x13) v(xc1_5.xl.xfe.x14)
+ v(xc1_5.xl.xfe.x15) v(xc1_5.xl.xfe.x16) v(xc1_5.xl.m) v(xc1_5.xr.xfe.x1) v(xc1_5.xr.xfe.x2) v(xc1_5.xr.xfe.x3) v(xc1_5.xr.xfe.x4) v(xc1_5.xr.xfe.x5)
+ v(xc1_5.xr.xfe.x6) v(xc1_5.xr.xfe.x7) v(xc1_5.xr.xfe.x8) v(xc1_5.xr.xfe.x9) v(xc1_5.xr.xfe.x10) v(xc1_5.xr.xfe.x11) v(xc1_5.xr.xfe.x12) v(xc1_5.xr.xfe.x13)
+ v(xc1_5.xr.xfe.x14) v(xc1_5.xr.xfe.x15) v(xc1_5.xr.xfe.x16) v(xc1_5.xr.m) v(xc1_6.xl.xfe.x1) v(xc1_6.xl.xfe.x2) v(xc1_6.xl.xfe.x3) v(xc1_6.xl.xfe.x4)
+ v(xc1_6.xl.xfe.x5) v(xc1_6.xl.xfe.x6) v(xc1_6.xl.xfe.x7) v(xc1_6.xl.xfe.x8) v(xc1_6.xl.xfe.x9) v(xc1_6.xl.xfe.x10) v(xc1_6.xl.xfe.x11) v(xc1_6.xl.xfe.x12)
+ v(xc1_6.xl.xfe.x13) v(xc1_6.xl.xfe.x14) v(xc1_6.xl.xfe.x15) v(xc1_6.xl.xfe.x16) v(xc1_6.xl.m) v(xc1_6.xr.xfe.x1) v(xc1_6.xr.xfe.x2) v(xc1_6.xr.xfe.x3)
+ v(xc1_6.xr.xfe.x4) v(xc1_6.xr.xfe.x5) v(xc1_6.xr.xfe.x6) v(xc1_6.xr.xfe.x7) v(xc1_6.xr.xfe.x8) v(xc1_6.xr.xfe.x9) v(xc1_6.xr.xfe.x10) v(xc1_6.xr.xfe.x11)
+ v(xc1_6.xr.xfe.x12) v(xc1_6.xr.xfe.x13) v(xc1_6.xr.xfe.x14) v(xc1_6.xr.xfe.x15) v(xc1_6.xr.xfe.x16) v(xc1_6.xr.m) v(xc1_7.xl.xfe.x1) v(xc1_7.xl.xfe.x2)
+ v(xc1_7.xl.xfe.x3) v(xc1_7.xl.xfe.x4) v(xc1_7.xl.xfe.x5) v(xc1_7.xl.xfe.x6) v(xc1_7.xl.xfe.x7) v(xc1_7.xl.xfe.x8) v(xc1_7.xl.xfe.x9) v(xc1_7.xl.xfe.x10)
+ v(xc1_7.xl.xfe.x11) v(xc1_7.xl.xfe.x12) v(xc1_7.xl.xfe.x13) v(xc1_7.xl.xfe.x14) v(xc1_7.xl.xfe.x15) v(xc1_7.xl.xfe.x16) v(xc1_7.xl.m) v(xc1_7.xr.xfe.x1)
+ v(xc1_7.xr.xfe.x2) v(xc1_7.xr.xfe.x3) v(xc1_7.xr.xfe.x4) v(xc1_7.xr.xfe.x5) v(xc1_7.xr.xfe.x6) v(xc1_7.xr.xfe.x7) v(xc1_7.xr.xfe.x8) v(xc1_7.xr.xfe.x9)
+ v(xc1_7.xr.xfe.x10) v(xc1_7.xr.xfe.x11) v(xc1_7.xr.xfe.x12) v(xc1_7.xr.xfe.x13) v(xc1_7.xr.xfe.x14) v(xc1_7.xr.xfe.x15) v(xc1_7.xr.xfe.x16) v(xc1_7.xr.m)
.endc
.end
