* t3b_word8.cir -- generated by circuit/tcam/make_tcam.py search
* Test 3b: 8-cell words (one per case), nominal devices, two search cycles (the second is measured).
* VDD = 1.0 V, V_S = 1.1 V, precharge 0.8 ns, evaluate 2.8 ns.
* word 0: count 0: stored 10110100 key 10110100
* word 1: count 1: stored 10110100 key 00110100
* word 2: count 2: stored 10110100 key 01110100
* word 3: count 3: stored 10110100 key 01010100
* word 4: count 4: stored 10110100 key 01000100
* word 5: count 5: stored 10110100 key 01001100
* word 6: count 6: stored 10110100 key 01001000
* word 7: count 7: stored 10110100 key 01001010
* word 8: count 8: stored 10110100 key 01001011
* word 9: pricer {0,X}: 2: stored 11110000 key XX000000
* word 10: pricer {0,X}: 0: stored 11110000 key XXXXXXXX
* word 11: pricer {0,X}: 4: stored 11110000 key 00000000
* word 12: stored X: 0: stored 1X0X1X0X key 10011001
* word 13: stored X: 2: stored 1X0X1X0X key 01111100
* Full FeFET model (fefet_c16).
.include ../../device/ngspice/fefet_preisach.lib
.include ../../models/mosfet/standin45_bsim4.lib
.include tcam_cells.lib
.options reltol=1e-3 abstol=1e-15 method=gear
Vpreb preb 0 pwl(
+ 0 0 1e-09 0 1.02e-09 1 4.18e-09 1 4.2e-09 0 5e-09 0
+ 5.02e-09 1 8.18e-09 1 8.2e-09 0)
Vact in_act 0 pwl(
+ 0 1.1 1.2e-09 1.1 1.22e-09 0 4e-09 0 4.02e-09 1.1 5.2e-09 1.1
+ 5.22e-09 0 8e-09 0 8.02e-09 1.1)
* word 0: stored 10110100 key 10110100 -> 0 mismatch(es)
Vdd0 vdd0 0 1.0
Vs0 vs0 0 1.1
Xd0_0a in_act sl0_0 vs0 sldrv
Xd0_0b vs0 slb0_0 vs0 sldrv
Cs0_0a sl0_0 0 1e-16
Cs0_0b slb0_0 0 1e-16
Xc0_0 sl0_0 slb0_0 ml0_0 0 0 tcam2f dvgl=0 dvgr=0 xl1=-1 xl2=-1 xl3=-1 xl4=-1 xl5=-1 xl6=-1
+ xl7=-1 xl8=-1 xl9=-1 xl10=-1 xl11=-1 xl12=-1 xl13=-1 xl14=-1
+ xl15=-1 xl16=-1 xr1=1 xr2=1 xr3=1 xr4=1 xr5=1 xr6=1
+ xr7=1 xr8=1 xr9=1 xr10=1 xr11=1 xr12=1 xr13=1 xr14=0.999999988
+ xr15=1.00000021 xr16=0.999959662
.ic v(xc0_0.xl.m)=-0.277154442 v(xc0_0.xr.m)=0.424804359
Cm0_0 ml0_0 0 1e-16
Rm0_0 ml0_0 ml0_1 3.2
Xd0_1a vs0 sl0_1 vs0 sldrv
Xd0_1b in_act slb0_1 vs0 sldrv
Cs0_1a sl0_1 0 1e-16
Cs0_1b slb0_1 0 1e-16
Xc0_1 sl0_1 slb0_1 ml0_1 0 0 tcam2f dvgl=0 dvgr=0 xl1=1 xl2=1 xl3=1 xl4=1 xl5=1 xl6=1
+ xl7=1 xl8=1 xl9=1 xl10=1 xl11=1 xl12=1 xl13=1 xl14=0.999999988
+ xl15=1.00000021 xl16=0.999959662 xr1=-1 xr2=-1 xr3=-1 xr4=-1 xr5=-1 xr6=-1
+ xr7=-1 xr8=-1 xr9=-1 xr10=-1 xr11=-1 xr12=-1 xr13=-1 xr14=-1
+ xr15=-1 xr16=-1
.ic v(xc0_1.xl.m)=0.424804359 v(xc0_1.xr.m)=-0.277154442
Cm0_1 ml0_1 0 1e-16
Rm0_1 ml0_1 ml0_2 3.2
Xd0_2a in_act sl0_2 vs0 sldrv
Xd0_2b vs0 slb0_2 vs0 sldrv
Cs0_2a sl0_2 0 1e-16
Cs0_2b slb0_2 0 1e-16
Xc0_2 sl0_2 slb0_2 ml0_2 0 0 tcam2f dvgl=0 dvgr=0 xl1=-1 xl2=-1 xl3=-1 xl4=-1 xl5=-1 xl6=-1
+ xl7=-1 xl8=-1 xl9=-1 xl10=-1 xl11=-1 xl12=-1 xl13=-1 xl14=-1
+ xl15=-1 xl16=-1 xr1=1 xr2=1 xr3=1 xr4=1 xr5=1 xr6=1
+ xr7=1 xr8=1 xr9=1 xr10=1 xr11=1 xr12=1 xr13=1 xr14=0.999999988
+ xr15=1.00000021 xr16=0.999959662
.ic v(xc0_2.xl.m)=-0.277154442 v(xc0_2.xr.m)=0.424804359
Cm0_2 ml0_2 0 1e-16
Rm0_2 ml0_2 ml0_3 3.2
Xd0_3a in_act sl0_3 vs0 sldrv
Xd0_3b vs0 slb0_3 vs0 sldrv
Cs0_3a sl0_3 0 1e-16
Cs0_3b slb0_3 0 1e-16
Xc0_3 sl0_3 slb0_3 ml0_3 0 0 tcam2f dvgl=0 dvgr=0 xl1=-1 xl2=-1 xl3=-1 xl4=-1 xl5=-1 xl6=-1
+ xl7=-1 xl8=-1 xl9=-1 xl10=-1 xl11=-1 xl12=-1 xl13=-1 xl14=-1
+ xl15=-1 xl16=-1 xr1=1 xr2=1 xr3=1 xr4=1 xr5=1 xr6=1
+ xr7=1 xr8=1 xr9=1 xr10=1 xr11=1 xr12=1 xr13=1 xr14=0.999999988
+ xr15=1.00000021 xr16=0.999959662
.ic v(xc0_3.xl.m)=-0.277154442 v(xc0_3.xr.m)=0.424804359
Cm0_3 ml0_3 0 1e-16
Rm0_3 ml0_3 ml0_4 3.2
Xd0_4a vs0 sl0_4 vs0 sldrv
Xd0_4b in_act slb0_4 vs0 sldrv
Cs0_4a sl0_4 0 1e-16
Cs0_4b slb0_4 0 1e-16
Xc0_4 sl0_4 slb0_4 ml0_4 0 0 tcam2f dvgl=0 dvgr=0 xl1=1 xl2=1 xl3=1 xl4=1 xl5=1 xl6=1
+ xl7=1 xl8=1 xl9=1 xl10=1 xl11=1 xl12=1 xl13=1 xl14=0.999999988
+ xl15=1.00000021 xl16=0.999959662 xr1=-1 xr2=-1 xr3=-1 xr4=-1 xr5=-1 xr6=-1
+ xr7=-1 xr8=-1 xr9=-1 xr10=-1 xr11=-1 xr12=-1 xr13=-1 xr14=-1
+ xr15=-1 xr16=-1
.ic v(xc0_4.xl.m)=0.424804359 v(xc0_4.xr.m)=-0.277154442
Cm0_4 ml0_4 0 1e-16
Rm0_4 ml0_4 ml0_5 3.2
Xd0_5a in_act sl0_5 vs0 sldrv
Xd0_5b vs0 slb0_5 vs0 sldrv
Cs0_5a sl0_5 0 1e-16
Cs0_5b slb0_5 0 1e-16
Xc0_5 sl0_5 slb0_5 ml0_5 0 0 tcam2f dvgl=0 dvgr=0 xl1=-1 xl2=-1 xl3=-1 xl4=-1 xl5=-1 xl6=-1
+ xl7=-1 xl8=-1 xl9=-1 xl10=-1 xl11=-1 xl12=-1 xl13=-1 xl14=-1
+ xl15=-1 xl16=-1 xr1=1 xr2=1 xr3=1 xr4=1 xr5=1 xr6=1
+ xr7=1 xr8=1 xr9=1 xr10=1 xr11=1 xr12=1 xr13=1 xr14=0.999999988
+ xr15=1.00000021 xr16=0.999959662
.ic v(xc0_5.xl.m)=-0.277154442 v(xc0_5.xr.m)=0.424804359
Cm0_5 ml0_5 0 1e-16
Rm0_5 ml0_5 ml0_6 3.2
Xd0_6a vs0 sl0_6 vs0 sldrv
Xd0_6b in_act slb0_6 vs0 sldrv
Cs0_6a sl0_6 0 1e-16
Cs0_6b slb0_6 0 1e-16
Xc0_6 sl0_6 slb0_6 ml0_6 0 0 tcam2f dvgl=0 dvgr=0 xl1=1 xl2=1 xl3=1 xl4=1 xl5=1 xl6=1
+ xl7=1 xl8=1 xl9=1 xl10=1 xl11=1 xl12=1 xl13=1 xl14=0.999999988
+ xl15=1.00000021 xl16=0.999959662 xr1=-1 xr2=-1 xr3=-1 xr4=-1 xr5=-1 xr6=-1
+ xr7=-1 xr8=-1 xr9=-1 xr10=-1 xr11=-1 xr12=-1 xr13=-1 xr14=-1
+ xr15=-1 xr16=-1
.ic v(xc0_6.xl.m)=0.424804359 v(xc0_6.xr.m)=-0.277154442
Cm0_6 ml0_6 0 1e-16
Rm0_6 ml0_6 ml0_7 3.2
Xd0_7a vs0 sl0_7 vs0 sldrv
Xd0_7b in_act slb0_7 vs0 sldrv
Cs0_7a sl0_7 0 1e-16
Cs0_7b slb0_7 0 1e-16
Xc0_7 sl0_7 slb0_7 ml0_7 0 0 tcam2f dvgl=0 dvgr=0 xl1=1 xl2=1 xl3=1 xl4=1 xl5=1 xl6=1
+ xl7=1 xl8=1 xl9=1 xl10=1 xl11=1 xl12=1 xl13=1 xl14=0.999999988
+ xl15=1.00000021 xl16=0.999959662 xr1=-1 xr2=-1 xr3=-1 xr4=-1 xr5=-1 xr6=-1
+ xr7=-1 xr8=-1 xr9=-1 xr10=-1 xr11=-1 xr12=-1 xr13=-1 xr14=-1
+ xr15=-1 xr16=-1
.ic v(xc0_7.xl.m)=0.424804359 v(xc0_7.xr.m)=-0.277154442
Cm0_7 ml0_7 0 1e-16
Xp0 ml0_0 preb vdd0 mlpre
Xsa0 ml0_0 miss0 match0 vdd0 mlsa
.ic v(ml0_0)=1.0 v(ml0_1)=1.0 v(ml0_2)=1.0 v(ml0_3)=1.0 v(ml0_4)=1.0 v(ml0_5)=1.0 v(ml0_6)=1.0 v(ml0_7)=1.0 v(match0)=1.0
* word 1: stored 10110100 key 00110100 -> 1 mismatch(es)
Vdd1 vdd1 0 1.0
Vs1 vs1 0 1.1
Xd1_0a vs1 sl1_0 vs1 sldrv
Xd1_0b in_act slb1_0 vs1 sldrv
Cs1_0a sl1_0 0 1e-16
Cs1_0b slb1_0 0 1e-16
Xc1_0 sl1_0 slb1_0 ml1_0 0 0 tcam2f dvgl=0 dvgr=0 xl1=-1 xl2=-1 xl3=-1 xl4=-1 xl5=-1 xl6=-1
+ xl7=-1 xl8=-1 xl9=-1 xl10=-1 xl11=-1 xl12=-1 xl13=-1 xl14=-1
+ xl15=-1 xl16=-1 xr1=1 xr2=1 xr3=1 xr4=1 xr5=1 xr6=1
+ xr7=1 xr8=1 xr9=1 xr10=1 xr11=1 xr12=1 xr13=1 xr14=0.999999988
+ xr15=1.00000021 xr16=0.999959662
.ic v(xc1_0.xl.m)=-0.277154442 v(xc1_0.xr.m)=0.424804359
Cm1_0 ml1_0 0 1e-16
Rm1_0 ml1_0 ml1_1 3.2
Xd1_1a vs1 sl1_1 vs1 sldrv
Xd1_1b in_act slb1_1 vs1 sldrv
Cs1_1a sl1_1 0 1e-16
Cs1_1b slb1_1 0 1e-16
Xc1_1 sl1_1 slb1_1 ml1_1 0 0 tcam2f dvgl=0 dvgr=0 xl1=1 xl2=1 xl3=1 xl4=1 xl5=1 xl6=1
+ xl7=1 xl8=1 xl9=1 xl10=1 xl11=1 xl12=1 xl13=1 xl14=0.999999988
+ xl15=1.00000021 xl16=0.999959662 xr1=-1 xr2=-1 xr3=-1 xr4=-1 xr5=-1 xr6=-1
+ xr7=-1 xr8=-1 xr9=-1 xr10=-1 xr11=-1 xr12=-1 xr13=-1 xr14=-1
+ xr15=-1 xr16=-1
.ic v(xc1_1.xl.m)=0.424804359 v(xc1_1.xr.m)=-0.277154442
Cm1_1 ml1_1 0 1e-16
Rm1_1 ml1_1 ml1_2 3.2
Xd1_2a in_act sl1_2 vs1 sldrv
Xd1_2b vs1 slb1_2 vs1 sldrv
Cs1_2a sl1_2 0 1e-16
Cs1_2b slb1_2 0 1e-16
Xc1_2 sl1_2 slb1_2 ml1_2 0 0 tcam2f dvgl=0 dvgr=0 xl1=-1 xl2=-1 xl3=-1 xl4=-1 xl5=-1 xl6=-1
+ xl7=-1 xl8=-1 xl9=-1 xl10=-1 xl11=-1 xl12=-1 xl13=-1 xl14=-1
+ xl15=-1 xl16=-1 xr1=1 xr2=1 xr3=1 xr4=1 xr5=1 xr6=1
+ xr7=1 xr8=1 xr9=1 xr10=1 xr11=1 xr12=1 xr13=1 xr14=0.999999988
+ xr15=1.00000021 xr16=0.999959662
.ic v(xc1_2.xl.m)=-0.277154442 v(xc1_2.xr.m)=0.424804359
Cm1_2 ml1_2 0 1e-16
Rm1_2 ml1_2 ml1_3 3.2
Xd1_3a in_act sl1_3 vs1 sldrv
Xd1_3b vs1 slb1_3 vs1 sldrv
Cs1_3a sl1_3 0 1e-16
Cs1_3b slb1_3 0 1e-16
Xc1_3 sl1_3 slb1_3 ml1_3 0 0 tcam2f dvgl=0 dvgr=0 xl1=-1 xl2=-1 xl3=-1 xl4=-1 xl5=-1 xl6=-1
+ xl7=-1 xl8=-1 xl9=-1 xl10=-1 xl11=-1 xl12=-1 xl13=-1 xl14=-1
+ xl15=-1 xl16=-1 xr1=1 xr2=1 xr3=1 xr4=1 xr5=1 xr6=1
+ xr7=1 xr8=1 xr9=1 xr10=1 xr11=1 xr12=1 xr13=1 xr14=0.999999988
+ xr15=1.00000021 xr16=0.999959662
.ic v(xc1_3.xl.m)=-0.277154442 v(xc1_3.xr.m)=0.424804359
Cm1_3 ml1_3 0 1e-16
Rm1_3 ml1_3 ml1_4 3.2
Xd1_4a vs1 sl1_4 vs1 sldrv
Xd1_4b in_act slb1_4 vs1 sldrv
Cs1_4a sl1_4 0 1e-16
Cs1_4b slb1_4 0 1e-16
Xc1_4 sl1_4 slb1_4 ml1_4 0 0 tcam2f dvgl=0 dvgr=0 xl1=1 xl2=1 xl3=1 xl4=1 xl5=1 xl6=1
+ xl7=1 xl8=1 xl9=1 xl10=1 xl11=1 xl12=1 xl13=1 xl14=0.999999988
+ xl15=1.00000021 xl16=0.999959662 xr1=-1 xr2=-1 xr3=-1 xr4=-1 xr5=-1 xr6=-1
+ xr7=-1 xr8=-1 xr9=-1 xr10=-1 xr11=-1 xr12=-1 xr13=-1 xr14=-1
+ xr15=-1 xr16=-1
.ic v(xc1_4.xl.m)=0.424804359 v(xc1_4.xr.m)=-0.277154442
Cm1_4 ml1_4 0 1e-16
Rm1_4 ml1_4 ml1_5 3.2
Xd1_5a in_act sl1_5 vs1 sldrv
Xd1_5b vs1 slb1_5 vs1 sldrv
Cs1_5a sl1_5 0 1e-16
Cs1_5b slb1_5 0 1e-16
Xc1_5 sl1_5 slb1_5 ml1_5 0 0 tcam2f dvgl=0 dvgr=0 xl1=-1 xl2=-1 xl3=-1 xl4=-1 xl5=-1 xl6=-1
+ xl7=-1 xl8=-1 xl9=-1 xl10=-1 xl11=-1 xl12=-1 xl13=-1 xl14=-1
+ xl15=-1 xl16=-1 xr1=1 xr2=1 xr3=1 xr4=1 xr5=1 xr6=1
+ xr7=1 xr8=1 xr9=1 xr10=1 xr11=1 xr12=1 xr13=1 xr14=0.999999988
+ xr15=1.00000021 xr16=0.999959662
.ic v(xc1_5.xl.m)=-0.277154442 v(xc1_5.xr.m)=0.424804359
Cm1_5 ml1_5 0 1e-16
Rm1_5 ml1_5 ml1_6 3.2
Xd1_6a vs1 sl1_6 vs1 sldrv
Xd1_6b in_act slb1_6 vs1 sldrv
Cs1_6a sl1_6 0 1e-16
Cs1_6b slb1_6 0 1e-16
Xc1_6 sl1_6 slb1_6 ml1_6 0 0 tcam2f dvgl=0 dvgr=0 xl1=1 xl2=1 xl3=1 xl4=1 xl5=1 xl6=1
+ xl7=1 xl8=1 xl9=1 xl10=1 xl11=1 xl12=1 xl13=1 xl14=0.999999988
+ xl15=1.00000021 xl16=0.999959662 xr1=-1 xr2=-1 xr3=-1 xr4=-1 xr5=-1 xr6=-1
+ xr7=-1 xr8=-1 xr9=-1 xr10=-1 xr11=-1 xr12=-1 xr13=-1 xr14=-1
+ xr15=-1 xr16=-1
.ic v(xc1_6.xl.m)=0.424804359 v(xc1_6.xr.m)=-0.277154442
Cm1_6 ml1_6 0 1e-16
Rm1_6 ml1_6 ml1_7 3.2
Xd1_7a vs1 sl1_7 vs1 sldrv
Xd1_7b in_act slb1_7 vs1 sldrv
Cs1_7a sl1_7 0 1e-16
Cs1_7b slb1_7 0 1e-16
Xc1_7 sl1_7 slb1_7 ml1_7 0 0 tcam2f dvgl=0 dvgr=0 xl1=1 xl2=1 xl3=1 xl4=1 xl5=1 xl6=1
+ xl7=1 xl8=1 xl9=1 xl10=1 xl11=1 xl12=1 xl13=1 xl14=0.999999988
+ xl15=1.00000021 xl16=0.999959662 xr1=-1 xr2=-1 xr3=-1 xr4=-1 xr5=-1 xr6=-1
+ xr7=-1 xr8=-1 xr9=-1 xr10=-1 xr11=-1 xr12=-1 xr13=-1 xr14=-1
+ xr15=-1 xr16=-1
.ic v(xc1_7.xl.m)=0.424804359 v(xc1_7.xr.m)=-0.277154442
Cm1_7 ml1_7 0 1e-16
Xp1 ml1_0 preb vdd1 mlpre
Xsa1 ml1_0 miss1 match1 vdd1 mlsa
.ic v(ml1_0)=1.0 v(ml1_1)=1.0 v(ml1_2)=1.0 v(ml1_3)=1.0 v(ml1_4)=1.0 v(ml1_5)=1.0 v(ml1_6)=1.0 v(ml1_7)=1.0 v(match1)=1.0
* word 2: stored 10110100 key 01110100 -> 2 mismatch(es)
Vdd2 vdd2 0 1.0
Vs2 vs2 0 1.1
Xd2_0a vs2 sl2_0 vs2 sldrv
Xd2_0b in_act slb2_0 vs2 sldrv
Cs2_0a sl2_0 0 1e-16
Cs2_0b slb2_0 0 1e-16
Xc2_0 sl2_0 slb2_0 ml2_0 0 0 tcam2f dvgl=0 dvgr=0 xl1=-1 xl2=-1 xl3=-1 xl4=-1 xl5=-1 xl6=-1
+ xl7=-1 xl8=-1 xl9=-1 xl10=-1 xl11=-1 xl12=-1 xl13=-1 xl14=-1
+ xl15=-1 xl16=-1 xr1=1 xr2=1 xr3=1 xr4=1 xr5=1 xr6=1
+ xr7=1 xr8=1 xr9=1 xr10=1 xr11=1 xr12=1 xr13=1 xr14=0.999999988
+ xr15=1.00000021 xr16=0.999959662
.ic v(xc2_0.xl.m)=-0.277154442 v(xc2_0.xr.m)=0.424804359
Cm2_0 ml2_0 0 1e-16
Rm2_0 ml2_0 ml2_1 3.2
Xd2_1a in_act sl2_1 vs2 sldrv
Xd2_1b vs2 slb2_1 vs2 sldrv
Cs2_1a sl2_1 0 1e-16
Cs2_1b slb2_1 0 1e-16
Xc2_1 sl2_1 slb2_1 ml2_1 0 0 tcam2f dvgl=0 dvgr=0 xl1=1 xl2=1 xl3=1 xl4=1 xl5=1 xl6=1
+ xl7=1 xl8=1 xl9=1 xl10=1 xl11=1 xl12=1 xl13=1 xl14=0.999999988
+ xl15=1.00000021 xl16=0.999959662 xr1=-1 xr2=-1 xr3=-1 xr4=-1 xr5=-1 xr6=-1
+ xr7=-1 xr8=-1 xr9=-1 xr10=-1 xr11=-1 xr12=-1 xr13=-1 xr14=-1
+ xr15=-1 xr16=-1
.ic v(xc2_1.xl.m)=0.424804359 v(xc2_1.xr.m)=-0.277154442
Cm2_1 ml2_1 0 1e-16
Rm2_1 ml2_1 ml2_2 3.2
Xd2_2a in_act sl2_2 vs2 sldrv
Xd2_2b vs2 slb2_2 vs2 sldrv
Cs2_2a sl2_2 0 1e-16
Cs2_2b slb2_2 0 1e-16
Xc2_2 sl2_2 slb2_2 ml2_2 0 0 tcam2f dvgl=0 dvgr=0 xl1=-1 xl2=-1 xl3=-1 xl4=-1 xl5=-1 xl6=-1
+ xl7=-1 xl8=-1 xl9=-1 xl10=-1 xl11=-1 xl12=-1 xl13=-1 xl14=-1
+ xl15=-1 xl16=-1 xr1=1 xr2=1 xr3=1 xr4=1 xr5=1 xr6=1
+ xr7=1 xr8=1 xr9=1 xr10=1 xr11=1 xr12=1 xr13=1 xr14=0.999999988
+ xr15=1.00000021 xr16=0.999959662
.ic v(xc2_2.xl.m)=-0.277154442 v(xc2_2.xr.m)=0.424804359
Cm2_2 ml2_2 0 1e-16
Rm2_2 ml2_2 ml2_3 3.2
Xd2_3a in_act sl2_3 vs2 sldrv
Xd2_3b vs2 slb2_3 vs2 sldrv
Cs2_3a sl2_3 0 1e-16
Cs2_3b slb2_3 0 1e-16
Xc2_3 sl2_3 slb2_3 ml2_3 0 0 tcam2f dvgl=0 dvgr=0 xl1=-1 xl2=-1 xl3=-1 xl4=-1 xl5=-1 xl6=-1
+ xl7=-1 xl8=-1 xl9=-1 xl10=-1 xl11=-1 xl12=-1 xl13=-1 xl14=-1
+ xl15=-1 xl16=-1 xr1=1 xr2=1 xr3=1 xr4=1 xr5=1 xr6=1
+ xr7=1 xr8=1 xr9=1 xr10=1 xr11=1 xr12=1 xr13=1 xr14=0.999999988
+ xr15=1.00000021 xr16=0.999959662
.ic v(xc2_3.xl.m)=-0.277154442 v(xc2_3.xr.m)=0.424804359
Cm2_3 ml2_3 0 1e-16
Rm2_3 ml2_3 ml2_4 3.2
Xd2_4a vs2 sl2_4 vs2 sldrv
Xd2_4b in_act slb2_4 vs2 sldrv
Cs2_4a sl2_4 0 1e-16
Cs2_4b slb2_4 0 1e-16
Xc2_4 sl2_4 slb2_4 ml2_4 0 0 tcam2f dvgl=0 dvgr=0 xl1=1 xl2=1 xl3=1 xl4=1 xl5=1 xl6=1
+ xl7=1 xl8=1 xl9=1 xl10=1 xl11=1 xl12=1 xl13=1 xl14=0.999999988
+ xl15=1.00000021 xl16=0.999959662 xr1=-1 xr2=-1 xr3=-1 xr4=-1 xr5=-1 xr6=-1
+ xr7=-1 xr8=-1 xr9=-1 xr10=-1 xr11=-1 xr12=-1 xr13=-1 xr14=-1
+ xr15=-1 xr16=-1
.ic v(xc2_4.xl.m)=0.424804359 v(xc2_4.xr.m)=-0.277154442
Cm2_4 ml2_4 0 1e-16
Rm2_4 ml2_4 ml2_5 3.2
Xd2_5a in_act sl2_5 vs2 sldrv
Xd2_5b vs2 slb2_5 vs2 sldrv
Cs2_5a sl2_5 0 1e-16
Cs2_5b slb2_5 0 1e-16
Xc2_5 sl2_5 slb2_5 ml2_5 0 0 tcam2f dvgl=0 dvgr=0 xl1=-1 xl2=-1 xl3=-1 xl4=-1 xl5=-1 xl6=-1
+ xl7=-1 xl8=-1 xl9=-1 xl10=-1 xl11=-1 xl12=-1 xl13=-1 xl14=-1
+ xl15=-1 xl16=-1 xr1=1 xr2=1 xr3=1 xr4=1 xr5=1 xr6=1
+ xr7=1 xr8=1 xr9=1 xr10=1 xr11=1 xr12=1 xr13=1 xr14=0.999999988
+ xr15=1.00000021 xr16=0.999959662
.ic v(xc2_5.xl.m)=-0.277154442 v(xc2_5.xr.m)=0.424804359
Cm2_5 ml2_5 0 1e-16
Rm2_5 ml2_5 ml2_6 3.2
Xd2_6a vs2 sl2_6 vs2 sldrv
Xd2_6b in_act slb2_6 vs2 sldrv
Cs2_6a sl2_6 0 1e-16
Cs2_6b slb2_6 0 1e-16
Xc2_6 sl2_6 slb2_6 ml2_6 0 0 tcam2f dvgl=0 dvgr=0 xl1=1 xl2=1 xl3=1 xl4=1 xl5=1 xl6=1
+ xl7=1 xl8=1 xl9=1 xl10=1 xl11=1 xl12=1 xl13=1 xl14=0.999999988
+ xl15=1.00000021 xl16=0.999959662 xr1=-1 xr2=-1 xr3=-1 xr4=-1 xr5=-1 xr6=-1
+ xr7=-1 xr8=-1 xr9=-1 xr10=-1 xr11=-1 xr12=-1 xr13=-1 xr14=-1
+ xr15=-1 xr16=-1
.ic v(xc2_6.xl.m)=0.424804359 v(xc2_6.xr.m)=-0.277154442
Cm2_6 ml2_6 0 1e-16
Rm2_6 ml2_6 ml2_7 3.2
Xd2_7a vs2 sl2_7 vs2 sldrv
Xd2_7b in_act slb2_7 vs2 sldrv
Cs2_7a sl2_7 0 1e-16
Cs2_7b slb2_7 0 1e-16
Xc2_7 sl2_7 slb2_7 ml2_7 0 0 tcam2f dvgl=0 dvgr=0 xl1=1 xl2=1 xl3=1 xl4=1 xl5=1 xl6=1
+ xl7=1 xl8=1 xl9=1 xl10=1 xl11=1 xl12=1 xl13=1 xl14=0.999999988
+ xl15=1.00000021 xl16=0.999959662 xr1=-1 xr2=-1 xr3=-1 xr4=-1 xr5=-1 xr6=-1
+ xr7=-1 xr8=-1 xr9=-1 xr10=-1 xr11=-1 xr12=-1 xr13=-1 xr14=-1
+ xr15=-1 xr16=-1
.ic v(xc2_7.xl.m)=0.424804359 v(xc2_7.xr.m)=-0.277154442
Cm2_7 ml2_7 0 1e-16
Xp2 ml2_0 preb vdd2 mlpre
Xsa2 ml2_0 miss2 match2 vdd2 mlsa
.ic v(ml2_0)=1.0 v(ml2_1)=1.0 v(ml2_2)=1.0 v(ml2_3)=1.0 v(ml2_4)=1.0 v(ml2_5)=1.0 v(ml2_6)=1.0 v(ml2_7)=1.0 v(match2)=1.0
* word 3: stored 10110100 key 01010100 -> 3 mismatch(es)
Vdd3 vdd3 0 1.0
Vs3 vs3 0 1.1
Xd3_0a vs3 sl3_0 vs3 sldrv
Xd3_0b in_act slb3_0 vs3 sldrv
Cs3_0a sl3_0 0 1e-16
Cs3_0b slb3_0 0 1e-16
Xc3_0 sl3_0 slb3_0 ml3_0 0 0 tcam2f dvgl=0 dvgr=0 xl1=-1 xl2=-1 xl3=-1 xl4=-1 xl5=-1 xl6=-1
+ xl7=-1 xl8=-1 xl9=-1 xl10=-1 xl11=-1 xl12=-1 xl13=-1 xl14=-1
+ xl15=-1 xl16=-1 xr1=1 xr2=1 xr3=1 xr4=1 xr5=1 xr6=1
+ xr7=1 xr8=1 xr9=1 xr10=1 xr11=1 xr12=1 xr13=1 xr14=0.999999988
+ xr15=1.00000021 xr16=0.999959662
.ic v(xc3_0.xl.m)=-0.277154442 v(xc3_0.xr.m)=0.424804359
Cm3_0 ml3_0 0 1e-16
Rm3_0 ml3_0 ml3_1 3.2
Xd3_1a in_act sl3_1 vs3 sldrv
Xd3_1b vs3 slb3_1 vs3 sldrv
Cs3_1a sl3_1 0 1e-16
Cs3_1b slb3_1 0 1e-16
Xc3_1 sl3_1 slb3_1 ml3_1 0 0 tcam2f dvgl=0 dvgr=0 xl1=1 xl2=1 xl3=1 xl4=1 xl5=1 xl6=1
+ xl7=1 xl8=1 xl9=1 xl10=1 xl11=1 xl12=1 xl13=1 xl14=0.999999988
+ xl15=1.00000021 xl16=0.999959662 xr1=-1 xr2=-1 xr3=-1 xr4=-1 xr5=-1 xr6=-1
+ xr7=-1 xr8=-1 xr9=-1 xr10=-1 xr11=-1 xr12=-1 xr13=-1 xr14=-1
+ xr15=-1 xr16=-1
.ic v(xc3_1.xl.m)=0.424804359 v(xc3_1.xr.m)=-0.277154442
Cm3_1 ml3_1 0 1e-16
Rm3_1 ml3_1 ml3_2 3.2
Xd3_2a vs3 sl3_2 vs3 sldrv
Xd3_2b in_act slb3_2 vs3 sldrv
Cs3_2a sl3_2 0 1e-16
Cs3_2b slb3_2 0 1e-16
Xc3_2 sl3_2 slb3_2 ml3_2 0 0 tcam2f dvgl=0 dvgr=0 xl1=-1 xl2=-1 xl3=-1 xl4=-1 xl5=-1 xl6=-1
+ xl7=-1 xl8=-1 xl9=-1 xl10=-1 xl11=-1 xl12=-1 xl13=-1 xl14=-1
+ xl15=-1 xl16=-1 xr1=1 xr2=1 xr3=1 xr4=1 xr5=1 xr6=1
+ xr7=1 xr8=1 xr9=1 xr10=1 xr11=1 xr12=1 xr13=1 xr14=0.999999988
+ xr15=1.00000021 xr16=0.999959662
.ic v(xc3_2.xl.m)=-0.277154442 v(xc3_2.xr.m)=0.424804359
Cm3_2 ml3_2 0 1e-16
Rm3_2 ml3_2 ml3_3 3.2
Xd3_3a in_act sl3_3 vs3 sldrv
Xd3_3b vs3 slb3_3 vs3 sldrv
Cs3_3a sl3_3 0 1e-16
Cs3_3b slb3_3 0 1e-16
Xc3_3 sl3_3 slb3_3 ml3_3 0 0 tcam2f dvgl=0 dvgr=0 xl1=-1 xl2=-1 xl3=-1 xl4=-1 xl5=-1 xl6=-1
+ xl7=-1 xl8=-1 xl9=-1 xl10=-1 xl11=-1 xl12=-1 xl13=-1 xl14=-1
+ xl15=-1 xl16=-1 xr1=1 xr2=1 xr3=1 xr4=1 xr5=1 xr6=1
+ xr7=1 xr8=1 xr9=1 xr10=1 xr11=1 xr12=1 xr13=1 xr14=0.999999988
+ xr15=1.00000021 xr16=0.999959662
.ic v(xc3_3.xl.m)=-0.277154442 v(xc3_3.xr.m)=0.424804359
Cm3_3 ml3_3 0 1e-16
Rm3_3 ml3_3 ml3_4 3.2
Xd3_4a vs3 sl3_4 vs3 sldrv
Xd3_4b in_act slb3_4 vs3 sldrv
Cs3_4a sl3_4 0 1e-16
Cs3_4b slb3_4 0 1e-16
Xc3_4 sl3_4 slb3_4 ml3_4 0 0 tcam2f dvgl=0 dvgr=0 xl1=1 xl2=1 xl3=1 xl4=1 xl5=1 xl6=1
+ xl7=1 xl8=1 xl9=1 xl10=1 xl11=1 xl12=1 xl13=1 xl14=0.999999988
+ xl15=1.00000021 xl16=0.999959662 xr1=-1 xr2=-1 xr3=-1 xr4=-1 xr5=-1 xr6=-1
+ xr7=-1 xr8=-1 xr9=-1 xr10=-1 xr11=-1 xr12=-1 xr13=-1 xr14=-1
+ xr15=-1 xr16=-1
.ic v(xc3_4.xl.m)=0.424804359 v(xc3_4.xr.m)=-0.277154442
Cm3_4 ml3_4 0 1e-16
Rm3_4 ml3_4 ml3_5 3.2
Xd3_5a in_act sl3_5 vs3 sldrv
Xd3_5b vs3 slb3_5 vs3 sldrv
Cs3_5a sl3_5 0 1e-16
Cs3_5b slb3_5 0 1e-16
Xc3_5 sl3_5 slb3_5 ml3_5 0 0 tcam2f dvgl=0 dvgr=0 xl1=-1 xl2=-1 xl3=-1 xl4=-1 xl5=-1 xl6=-1
+ xl7=-1 xl8=-1 xl9=-1 xl10=-1 xl11=-1 xl12=-1 xl13=-1 xl14=-1
+ xl15=-1 xl16=-1 xr1=1 xr2=1 xr3=1 xr4=1 xr5=1 xr6=1
+ xr7=1 xr8=1 xr9=1 xr10=1 xr11=1 xr12=1 xr13=1 xr14=0.999999988
+ xr15=1.00000021 xr16=0.999959662
.ic v(xc3_5.xl.m)=-0.277154442 v(xc3_5.xr.m)=0.424804359
Cm3_5 ml3_5 0 1e-16
Rm3_5 ml3_5 ml3_6 3.2
Xd3_6a vs3 sl3_6 vs3 sldrv
Xd3_6b in_act slb3_6 vs3 sldrv
Cs3_6a sl3_6 0 1e-16
Cs3_6b slb3_6 0 1e-16
Xc3_6 sl3_6 slb3_6 ml3_6 0 0 tcam2f dvgl=0 dvgr=0 xl1=1 xl2=1 xl3=1 xl4=1 xl5=1 xl6=1
+ xl7=1 xl8=1 xl9=1 xl10=1 xl11=1 xl12=1 xl13=1 xl14=0.999999988
+ xl15=1.00000021 xl16=0.999959662 xr1=-1 xr2=-1 xr3=-1 xr4=-1 xr5=-1 xr6=-1
+ xr7=-1 xr8=-1 xr9=-1 xr10=-1 xr11=-1 xr12=-1 xr13=-1 xr14=-1
+ xr15=-1 xr16=-1
.ic v(xc3_6.xl.m)=0.424804359 v(xc3_6.xr.m)=-0.277154442
Cm3_6 ml3_6 0 1e-16
Rm3_6 ml3_6 ml3_7 3.2
Xd3_7a vs3 sl3_7 vs3 sldrv
Xd3_7b in_act slb3_7 vs3 sldrv
Cs3_7a sl3_7 0 1e-16
Cs3_7b slb3_7 0 1e-16
Xc3_7 sl3_7 slb3_7 ml3_7 0 0 tcam2f dvgl=0 dvgr=0 xl1=1 xl2=1 xl3=1 xl4=1 xl5=1 xl6=1
+ xl7=1 xl8=1 xl9=1 xl10=1 xl11=1 xl12=1 xl13=1 xl14=0.999999988
+ xl15=1.00000021 xl16=0.999959662 xr1=-1 xr2=-1 xr3=-1 xr4=-1 xr5=-1 xr6=-1
+ xr7=-1 xr8=-1 xr9=-1 xr10=-1 xr11=-1 xr12=-1 xr13=-1 xr14=-1
+ xr15=-1 xr16=-1
.ic v(xc3_7.xl.m)=0.424804359 v(xc3_7.xr.m)=-0.277154442
Cm3_7 ml3_7 0 1e-16
Xp3 ml3_0 preb vdd3 mlpre
Xsa3 ml3_0 miss3 match3 vdd3 mlsa
.ic v(ml3_0)=1.0 v(ml3_1)=1.0 v(ml3_2)=1.0 v(ml3_3)=1.0 v(ml3_4)=1.0 v(ml3_5)=1.0 v(ml3_6)=1.0 v(ml3_7)=1.0 v(match3)=1.0
* word 4: stored 10110100 key 01000100 -> 4 mismatch(es)
Vdd4 vdd4 0 1.0
Vs4 vs4 0 1.1
Xd4_0a vs4 sl4_0 vs4 sldrv
Xd4_0b in_act slb4_0 vs4 sldrv
Cs4_0a sl4_0 0 1e-16
Cs4_0b slb4_0 0 1e-16
Xc4_0 sl4_0 slb4_0 ml4_0 0 0 tcam2f dvgl=0 dvgr=0 xl1=-1 xl2=-1 xl3=-1 xl4=-1 xl5=-1 xl6=-1
+ xl7=-1 xl8=-1 xl9=-1 xl10=-1 xl11=-1 xl12=-1 xl13=-1 xl14=-1
+ xl15=-1 xl16=-1 xr1=1 xr2=1 xr3=1 xr4=1 xr5=1 xr6=1
+ xr7=1 xr8=1 xr9=1 xr10=1 xr11=1 xr12=1 xr13=1 xr14=0.999999988
+ xr15=1.00000021 xr16=0.999959662
.ic v(xc4_0.xl.m)=-0.277154442 v(xc4_0.xr.m)=0.424804359
Cm4_0 ml4_0 0 1e-16
Rm4_0 ml4_0 ml4_1 3.2
Xd4_1a in_act sl4_1 vs4 sldrv
Xd4_1b vs4 slb4_1 vs4 sldrv
Cs4_1a sl4_1 0 1e-16
Cs4_1b slb4_1 0 1e-16
Xc4_1 sl4_1 slb4_1 ml4_1 0 0 tcam2f dvgl=0 dvgr=0 xl1=1 xl2=1 xl3=1 xl4=1 xl5=1 xl6=1
+ xl7=1 xl8=1 xl9=1 xl10=1 xl11=1 xl12=1 xl13=1 xl14=0.999999988
+ xl15=1.00000021 xl16=0.999959662 xr1=-1 xr2=-1 xr3=-1 xr4=-1 xr5=-1 xr6=-1
+ xr7=-1 xr8=-1 xr9=-1 xr10=-1 xr11=-1 xr12=-1 xr13=-1 xr14=-1
+ xr15=-1 xr16=-1
.ic v(xc4_1.xl.m)=0.424804359 v(xc4_1.xr.m)=-0.277154442
Cm4_1 ml4_1 0 1e-16
Rm4_1 ml4_1 ml4_2 3.2
Xd4_2a vs4 sl4_2 vs4 sldrv
Xd4_2b in_act slb4_2 vs4 sldrv
Cs4_2a sl4_2 0 1e-16
Cs4_2b slb4_2 0 1e-16
Xc4_2 sl4_2 slb4_2 ml4_2 0 0 tcam2f dvgl=0 dvgr=0 xl1=-1 xl2=-1 xl3=-1 xl4=-1 xl5=-1 xl6=-1
+ xl7=-1 xl8=-1 xl9=-1 xl10=-1 xl11=-1 xl12=-1 xl13=-1 xl14=-1
+ xl15=-1 xl16=-1 xr1=1 xr2=1 xr3=1 xr4=1 xr5=1 xr6=1
+ xr7=1 xr8=1 xr9=1 xr10=1 xr11=1 xr12=1 xr13=1 xr14=0.999999988
+ xr15=1.00000021 xr16=0.999959662
.ic v(xc4_2.xl.m)=-0.277154442 v(xc4_2.xr.m)=0.424804359
Cm4_2 ml4_2 0 1e-16
Rm4_2 ml4_2 ml4_3 3.2
Xd4_3a vs4 sl4_3 vs4 sldrv
Xd4_3b in_act slb4_3 vs4 sldrv
Cs4_3a sl4_3 0 1e-16
Cs4_3b slb4_3 0 1e-16
Xc4_3 sl4_3 slb4_3 ml4_3 0 0 tcam2f dvgl=0 dvgr=0 xl1=-1 xl2=-1 xl3=-1 xl4=-1 xl5=-1 xl6=-1
+ xl7=-1 xl8=-1 xl9=-1 xl10=-1 xl11=-1 xl12=-1 xl13=-1 xl14=-1
+ xl15=-1 xl16=-1 xr1=1 xr2=1 xr3=1 xr4=1 xr5=1 xr6=1
+ xr7=1 xr8=1 xr9=1 xr10=1 xr11=1 xr12=1 xr13=1 xr14=0.999999988
+ xr15=1.00000021 xr16=0.999959662
.ic v(xc4_3.xl.m)=-0.277154442 v(xc4_3.xr.m)=0.424804359
Cm4_3 ml4_3 0 1e-16
Rm4_3 ml4_3 ml4_4 3.2
Xd4_4a vs4 sl4_4 vs4 sldrv
Xd4_4b in_act slb4_4 vs4 sldrv
Cs4_4a sl4_4 0 1e-16
Cs4_4b slb4_4 0 1e-16
Xc4_4 sl4_4 slb4_4 ml4_4 0 0 tcam2f dvgl=0 dvgr=0 xl1=1 xl2=1 xl3=1 xl4=1 xl5=1 xl6=1
+ xl7=1 xl8=1 xl9=1 xl10=1 xl11=1 xl12=1 xl13=1 xl14=0.999999988
+ xl15=1.00000021 xl16=0.999959662 xr1=-1 xr2=-1 xr3=-1 xr4=-1 xr5=-1 xr6=-1
+ xr7=-1 xr8=-1 xr9=-1 xr10=-1 xr11=-1 xr12=-1 xr13=-1 xr14=-1
+ xr15=-1 xr16=-1
.ic v(xc4_4.xl.m)=0.424804359 v(xc4_4.xr.m)=-0.277154442
Cm4_4 ml4_4 0 1e-16
Rm4_4 ml4_4 ml4_5 3.2
Xd4_5a in_act sl4_5 vs4 sldrv
Xd4_5b vs4 slb4_5 vs4 sldrv
Cs4_5a sl4_5 0 1e-16
Cs4_5b slb4_5 0 1e-16
Xc4_5 sl4_5 slb4_5 ml4_5 0 0 tcam2f dvgl=0 dvgr=0 xl1=-1 xl2=-1 xl3=-1 xl4=-1 xl5=-1 xl6=-1
+ xl7=-1 xl8=-1 xl9=-1 xl10=-1 xl11=-1 xl12=-1 xl13=-1 xl14=-1
+ xl15=-1 xl16=-1 xr1=1 xr2=1 xr3=1 xr4=1 xr5=1 xr6=1
+ xr7=1 xr8=1 xr9=1 xr10=1 xr11=1 xr12=1 xr13=1 xr14=0.999999988
+ xr15=1.00000021 xr16=0.999959662
.ic v(xc4_5.xl.m)=-0.277154442 v(xc4_5.xr.m)=0.424804359
Cm4_5 ml4_5 0 1e-16
Rm4_5 ml4_5 ml4_6 3.2
Xd4_6a vs4 sl4_6 vs4 sldrv
Xd4_6b in_act slb4_6 vs4 sldrv
Cs4_6a sl4_6 0 1e-16
Cs4_6b slb4_6 0 1e-16
Xc4_6 sl4_6 slb4_6 ml4_6 0 0 tcam2f dvgl=0 dvgr=0 xl1=1 xl2=1 xl3=1 xl4=1 xl5=1 xl6=1
+ xl7=1 xl8=1 xl9=1 xl10=1 xl11=1 xl12=1 xl13=1 xl14=0.999999988
+ xl15=1.00000021 xl16=0.999959662 xr1=-1 xr2=-1 xr3=-1 xr4=-1 xr5=-1 xr6=-1
+ xr7=-1 xr8=-1 xr9=-1 xr10=-1 xr11=-1 xr12=-1 xr13=-1 xr14=-1
+ xr15=-1 xr16=-1
.ic v(xc4_6.xl.m)=0.424804359 v(xc4_6.xr.m)=-0.277154442
Cm4_6 ml4_6 0 1e-16
Rm4_6 ml4_6 ml4_7 3.2
Xd4_7a vs4 sl4_7 vs4 sldrv
Xd4_7b in_act slb4_7 vs4 sldrv
Cs4_7a sl4_7 0 1e-16
Cs4_7b slb4_7 0 1e-16
Xc4_7 sl4_7 slb4_7 ml4_7 0 0 tcam2f dvgl=0 dvgr=0 xl1=1 xl2=1 xl3=1 xl4=1 xl5=1 xl6=1
+ xl7=1 xl8=1 xl9=1 xl10=1 xl11=1 xl12=1 xl13=1 xl14=0.999999988
+ xl15=1.00000021 xl16=0.999959662 xr1=-1 xr2=-1 xr3=-1 xr4=-1 xr5=-1 xr6=-1
+ xr7=-1 xr8=-1 xr9=-1 xr10=-1 xr11=-1 xr12=-1 xr13=-1 xr14=-1
+ xr15=-1 xr16=-1
.ic v(xc4_7.xl.m)=0.424804359 v(xc4_7.xr.m)=-0.277154442
Cm4_7 ml4_7 0 1e-16
Xp4 ml4_0 preb vdd4 mlpre
Xsa4 ml4_0 miss4 match4 vdd4 mlsa
.ic v(ml4_0)=1.0 v(ml4_1)=1.0 v(ml4_2)=1.0 v(ml4_3)=1.0 v(ml4_4)=1.0 v(ml4_5)=1.0 v(ml4_6)=1.0 v(ml4_7)=1.0 v(match4)=1.0
* word 5: stored 10110100 key 01001100 -> 5 mismatch(es)
Vdd5 vdd5 0 1.0
Vs5 vs5 0 1.1
Xd5_0a vs5 sl5_0 vs5 sldrv
Xd5_0b in_act slb5_0 vs5 sldrv
Cs5_0a sl5_0 0 1e-16
Cs5_0b slb5_0 0 1e-16
Xc5_0 sl5_0 slb5_0 ml5_0 0 0 tcam2f dvgl=0 dvgr=0 xl1=-1 xl2=-1 xl3=-1 xl4=-1 xl5=-1 xl6=-1
+ xl7=-1 xl8=-1 xl9=-1 xl10=-1 xl11=-1 xl12=-1 xl13=-1 xl14=-1
+ xl15=-1 xl16=-1 xr1=1 xr2=1 xr3=1 xr4=1 xr5=1 xr6=1
+ xr7=1 xr8=1 xr9=1 xr10=1 xr11=1 xr12=1 xr13=1 xr14=0.999999988
+ xr15=1.00000021 xr16=0.999959662
.ic v(xc5_0.xl.m)=-0.277154442 v(xc5_0.xr.m)=0.424804359
Cm5_0 ml5_0 0 1e-16
Rm5_0 ml5_0 ml5_1 3.2
Xd5_1a in_act sl5_1 vs5 sldrv
Xd5_1b vs5 slb5_1 vs5 sldrv
Cs5_1a sl5_1 0 1e-16
Cs5_1b slb5_1 0 1e-16
Xc5_1 sl5_1 slb5_1 ml5_1 0 0 tcam2f dvgl=0 dvgr=0 xl1=1 xl2=1 xl3=1 xl4=1 xl5=1 xl6=1
+ xl7=1 xl8=1 xl9=1 xl10=1 xl11=1 xl12=1 xl13=1 xl14=0.999999988
+ xl15=1.00000021 xl16=0.999959662 xr1=-1 xr2=-1 xr3=-1 xr4=-1 xr5=-1 xr6=-1
+ xr7=-1 xr8=-1 xr9=-1 xr10=-1 xr11=-1 xr12=-1 xr13=-1 xr14=-1
+ xr15=-1 xr16=-1
.ic v(xc5_1.xl.m)=0.424804359 v(xc5_1.xr.m)=-0.277154442
Cm5_1 ml5_1 0 1e-16
Rm5_1 ml5_1 ml5_2 3.2
Xd5_2a vs5 sl5_2 vs5 sldrv
Xd5_2b in_act slb5_2 vs5 sldrv
Cs5_2a sl5_2 0 1e-16
Cs5_2b slb5_2 0 1e-16
Xc5_2 sl5_2 slb5_2 ml5_2 0 0 tcam2f dvgl=0 dvgr=0 xl1=-1 xl2=-1 xl3=-1 xl4=-1 xl5=-1 xl6=-1
+ xl7=-1 xl8=-1 xl9=-1 xl10=-1 xl11=-1 xl12=-1 xl13=-1 xl14=-1
+ xl15=-1 xl16=-1 xr1=1 xr2=1 xr3=1 xr4=1 xr5=1 xr6=1
+ xr7=1 xr8=1 xr9=1 xr10=1 xr11=1 xr12=1 xr13=1 xr14=0.999999988
+ xr15=1.00000021 xr16=0.999959662
.ic v(xc5_2.xl.m)=-0.277154442 v(xc5_2.xr.m)=0.424804359
Cm5_2 ml5_2 0 1e-16
Rm5_2 ml5_2 ml5_3 3.2
Xd5_3a vs5 sl5_3 vs5 sldrv
Xd5_3b in_act slb5_3 vs5 sldrv
Cs5_3a sl5_3 0 1e-16
Cs5_3b slb5_3 0 1e-16
Xc5_3 sl5_3 slb5_3 ml5_3 0 0 tcam2f dvgl=0 dvgr=0 xl1=-1 xl2=-1 xl3=-1 xl4=-1 xl5=-1 xl6=-1
+ xl7=-1 xl8=-1 xl9=-1 xl10=-1 xl11=-1 xl12=-1 xl13=-1 xl14=-1
+ xl15=-1 xl16=-1 xr1=1 xr2=1 xr3=1 xr4=1 xr5=1 xr6=1
+ xr7=1 xr8=1 xr9=1 xr10=1 xr11=1 xr12=1 xr13=1 xr14=0.999999988
+ xr15=1.00000021 xr16=0.999959662
.ic v(xc5_3.xl.m)=-0.277154442 v(xc5_3.xr.m)=0.424804359
Cm5_3 ml5_3 0 1e-16
Rm5_3 ml5_3 ml5_4 3.2
Xd5_4a in_act sl5_4 vs5 sldrv
Xd5_4b vs5 slb5_4 vs5 sldrv
Cs5_4a sl5_4 0 1e-16
Cs5_4b slb5_4 0 1e-16
Xc5_4 sl5_4 slb5_4 ml5_4 0 0 tcam2f dvgl=0 dvgr=0 xl1=1 xl2=1 xl3=1 xl4=1 xl5=1 xl6=1
+ xl7=1 xl8=1 xl9=1 xl10=1 xl11=1 xl12=1 xl13=1 xl14=0.999999988
+ xl15=1.00000021 xl16=0.999959662 xr1=-1 xr2=-1 xr3=-1 xr4=-1 xr5=-1 xr6=-1
+ xr7=-1 xr8=-1 xr9=-1 xr10=-1 xr11=-1 xr12=-1 xr13=-1 xr14=-1
+ xr15=-1 xr16=-1
.ic v(xc5_4.xl.m)=0.424804359 v(xc5_4.xr.m)=-0.277154442
Cm5_4 ml5_4 0 1e-16
Rm5_4 ml5_4 ml5_5 3.2
Xd5_5a in_act sl5_5 vs5 sldrv
Xd5_5b vs5 slb5_5 vs5 sldrv
Cs5_5a sl5_5 0 1e-16
Cs5_5b slb5_5 0 1e-16
Xc5_5 sl5_5 slb5_5 ml5_5 0 0 tcam2f dvgl=0 dvgr=0 xl1=-1 xl2=-1 xl3=-1 xl4=-1 xl5=-1 xl6=-1
+ xl7=-1 xl8=-1 xl9=-1 xl10=-1 xl11=-1 xl12=-1 xl13=-1 xl14=-1
+ xl15=-1 xl16=-1 xr1=1 xr2=1 xr3=1 xr4=1 xr5=1 xr6=1
+ xr7=1 xr8=1 xr9=1 xr10=1 xr11=1 xr12=1 xr13=1 xr14=0.999999988
+ xr15=1.00000021 xr16=0.999959662
.ic v(xc5_5.xl.m)=-0.277154442 v(xc5_5.xr.m)=0.424804359
Cm5_5 ml5_5 0 1e-16
Rm5_5 ml5_5 ml5_6 3.2
Xd5_6a vs5 sl5_6 vs5 sldrv
Xd5_6b in_act slb5_6 vs5 sldrv
Cs5_6a sl5_6 0 1e-16
Cs5_6b slb5_6 0 1e-16
Xc5_6 sl5_6 slb5_6 ml5_6 0 0 tcam2f dvgl=0 dvgr=0 xl1=1 xl2=1 xl3=1 xl4=1 xl5=1 xl6=1
+ xl7=1 xl8=1 xl9=1 xl10=1 xl11=1 xl12=1 xl13=1 xl14=0.999999988
+ xl15=1.00000021 xl16=0.999959662 xr1=-1 xr2=-1 xr3=-1 xr4=-1 xr5=-1 xr6=-1
+ xr7=-1 xr8=-1 xr9=-1 xr10=-1 xr11=-1 xr12=-1 xr13=-1 xr14=-1
+ xr15=-1 xr16=-1
.ic v(xc5_6.xl.m)=0.424804359 v(xc5_6.xr.m)=-0.277154442
Cm5_6 ml5_6 0 1e-16
Rm5_6 ml5_6 ml5_7 3.2
Xd5_7a vs5 sl5_7 vs5 sldrv
Xd5_7b in_act slb5_7 vs5 sldrv
Cs5_7a sl5_7 0 1e-16
Cs5_7b slb5_7 0 1e-16
Xc5_7 sl5_7 slb5_7 ml5_7 0 0 tcam2f dvgl=0 dvgr=0 xl1=1 xl2=1 xl3=1 xl4=1 xl5=1 xl6=1
+ xl7=1 xl8=1 xl9=1 xl10=1 xl11=1 xl12=1 xl13=1 xl14=0.999999988
+ xl15=1.00000021 xl16=0.999959662 xr1=-1 xr2=-1 xr3=-1 xr4=-1 xr5=-1 xr6=-1
+ xr7=-1 xr8=-1 xr9=-1 xr10=-1 xr11=-1 xr12=-1 xr13=-1 xr14=-1
+ xr15=-1 xr16=-1
.ic v(xc5_7.xl.m)=0.424804359 v(xc5_7.xr.m)=-0.277154442
Cm5_7 ml5_7 0 1e-16
Xp5 ml5_0 preb vdd5 mlpre
Xsa5 ml5_0 miss5 match5 vdd5 mlsa
.ic v(ml5_0)=1.0 v(ml5_1)=1.0 v(ml5_2)=1.0 v(ml5_3)=1.0 v(ml5_4)=1.0 v(ml5_5)=1.0 v(ml5_6)=1.0 v(ml5_7)=1.0 v(match5)=1.0
* word 6: stored 10110100 key 01001000 -> 6 mismatch(es)
Vdd6 vdd6 0 1.0
Vs6 vs6 0 1.1
Xd6_0a vs6 sl6_0 vs6 sldrv
Xd6_0b in_act slb6_0 vs6 sldrv
Cs6_0a sl6_0 0 1e-16
Cs6_0b slb6_0 0 1e-16
Xc6_0 sl6_0 slb6_0 ml6_0 0 0 tcam2f dvgl=0 dvgr=0 xl1=-1 xl2=-1 xl3=-1 xl4=-1 xl5=-1 xl6=-1
+ xl7=-1 xl8=-1 xl9=-1 xl10=-1 xl11=-1 xl12=-1 xl13=-1 xl14=-1
+ xl15=-1 xl16=-1 xr1=1 xr2=1 xr3=1 xr4=1 xr5=1 xr6=1
+ xr7=1 xr8=1 xr9=1 xr10=1 xr11=1 xr12=1 xr13=1 xr14=0.999999988
+ xr15=1.00000021 xr16=0.999959662
.ic v(xc6_0.xl.m)=-0.277154442 v(xc6_0.xr.m)=0.424804359
Cm6_0 ml6_0 0 1e-16
Rm6_0 ml6_0 ml6_1 3.2
Xd6_1a in_act sl6_1 vs6 sldrv
Xd6_1b vs6 slb6_1 vs6 sldrv
Cs6_1a sl6_1 0 1e-16
Cs6_1b slb6_1 0 1e-16
Xc6_1 sl6_1 slb6_1 ml6_1 0 0 tcam2f dvgl=0 dvgr=0 xl1=1 xl2=1 xl3=1 xl4=1 xl5=1 xl6=1
+ xl7=1 xl8=1 xl9=1 xl10=1 xl11=1 xl12=1 xl13=1 xl14=0.999999988
+ xl15=1.00000021 xl16=0.999959662 xr1=-1 xr2=-1 xr3=-1 xr4=-1 xr5=-1 xr6=-1
+ xr7=-1 xr8=-1 xr9=-1 xr10=-1 xr11=-1 xr12=-1 xr13=-1 xr14=-1
+ xr15=-1 xr16=-1
.ic v(xc6_1.xl.m)=0.424804359 v(xc6_1.xr.m)=-0.277154442
Cm6_1 ml6_1 0 1e-16
Rm6_1 ml6_1 ml6_2 3.2
Xd6_2a vs6 sl6_2 vs6 sldrv
Xd6_2b in_act slb6_2 vs6 sldrv
Cs6_2a sl6_2 0 1e-16
Cs6_2b slb6_2 0 1e-16
Xc6_2 sl6_2 slb6_2 ml6_2 0 0 tcam2f dvgl=0 dvgr=0 xl1=-1 xl2=-1 xl3=-1 xl4=-1 xl5=-1 xl6=-1
+ xl7=-1 xl8=-1 xl9=-1 xl10=-1 xl11=-1 xl12=-1 xl13=-1 xl14=-1
+ xl15=-1 xl16=-1 xr1=1 xr2=1 xr3=1 xr4=1 xr5=1 xr6=1
+ xr7=1 xr8=1 xr9=1 xr10=1 xr11=1 xr12=1 xr13=1 xr14=0.999999988
+ xr15=1.00000021 xr16=0.999959662
.ic v(xc6_2.xl.m)=-0.277154442 v(xc6_2.xr.m)=0.424804359
Cm6_2 ml6_2 0 1e-16
Rm6_2 ml6_2 ml6_3 3.2
Xd6_3a vs6 sl6_3 vs6 sldrv
Xd6_3b in_act slb6_3 vs6 sldrv
Cs6_3a sl6_3 0 1e-16
Cs6_3b slb6_3 0 1e-16
Xc6_3 sl6_3 slb6_3 ml6_3 0 0 tcam2f dvgl=0 dvgr=0 xl1=-1 xl2=-1 xl3=-1 xl4=-1 xl5=-1 xl6=-1
+ xl7=-1 xl8=-1 xl9=-1 xl10=-1 xl11=-1 xl12=-1 xl13=-1 xl14=-1
+ xl15=-1 xl16=-1 xr1=1 xr2=1 xr3=1 xr4=1 xr5=1 xr6=1
+ xr7=1 xr8=1 xr9=1 xr10=1 xr11=1 xr12=1 xr13=1 xr14=0.999999988
+ xr15=1.00000021 xr16=0.999959662
.ic v(xc6_3.xl.m)=-0.277154442 v(xc6_3.xr.m)=0.424804359
Cm6_3 ml6_3 0 1e-16
Rm6_3 ml6_3 ml6_4 3.2
Xd6_4a in_act sl6_4 vs6 sldrv
Xd6_4b vs6 slb6_4 vs6 sldrv
Cs6_4a sl6_4 0 1e-16
Cs6_4b slb6_4 0 1e-16
Xc6_4 sl6_4 slb6_4 ml6_4 0 0 tcam2f dvgl=0 dvgr=0 xl1=1 xl2=1 xl3=1 xl4=1 xl5=1 xl6=1
+ xl7=1 xl8=1 xl9=1 xl10=1 xl11=1 xl12=1 xl13=1 xl14=0.999999988
+ xl15=1.00000021 xl16=0.999959662 xr1=-1 xr2=-1 xr3=-1 xr4=-1 xr5=-1 xr6=-1
+ xr7=-1 xr8=-1 xr9=-1 xr10=-1 xr11=-1 xr12=-1 xr13=-1 xr14=-1
+ xr15=-1 xr16=-1
.ic v(xc6_4.xl.m)=0.424804359 v(xc6_4.xr.m)=-0.277154442
Cm6_4 ml6_4 0 1e-16
Rm6_4 ml6_4 ml6_5 3.2
Xd6_5a vs6 sl6_5 vs6 sldrv
Xd6_5b in_act slb6_5 vs6 sldrv
Cs6_5a sl6_5 0 1e-16
Cs6_5b slb6_5 0 1e-16
Xc6_5 sl6_5 slb6_5 ml6_5 0 0 tcam2f dvgl=0 dvgr=0 xl1=-1 xl2=-1 xl3=-1 xl4=-1 xl5=-1 xl6=-1
+ xl7=-1 xl8=-1 xl9=-1 xl10=-1 xl11=-1 xl12=-1 xl13=-1 xl14=-1
+ xl15=-1 xl16=-1 xr1=1 xr2=1 xr3=1 xr4=1 xr5=1 xr6=1
+ xr7=1 xr8=1 xr9=1 xr10=1 xr11=1 xr12=1 xr13=1 xr14=0.999999988
+ xr15=1.00000021 xr16=0.999959662
.ic v(xc6_5.xl.m)=-0.277154442 v(xc6_5.xr.m)=0.424804359
Cm6_5 ml6_5 0 1e-16
Rm6_5 ml6_5 ml6_6 3.2
Xd6_6a vs6 sl6_6 vs6 sldrv
Xd6_6b in_act slb6_6 vs6 sldrv
Cs6_6a sl6_6 0 1e-16
Cs6_6b slb6_6 0 1e-16
Xc6_6 sl6_6 slb6_6 ml6_6 0 0 tcam2f dvgl=0 dvgr=0 xl1=1 xl2=1 xl3=1 xl4=1 xl5=1 xl6=1
+ xl7=1 xl8=1 xl9=1 xl10=1 xl11=1 xl12=1 xl13=1 xl14=0.999999988
+ xl15=1.00000021 xl16=0.999959662 xr1=-1 xr2=-1 xr3=-1 xr4=-1 xr5=-1 xr6=-1
+ xr7=-1 xr8=-1 xr9=-1 xr10=-1 xr11=-1 xr12=-1 xr13=-1 xr14=-1
+ xr15=-1 xr16=-1
.ic v(xc6_6.xl.m)=0.424804359 v(xc6_6.xr.m)=-0.277154442
Cm6_6 ml6_6 0 1e-16
Rm6_6 ml6_6 ml6_7 3.2
Xd6_7a vs6 sl6_7 vs6 sldrv
Xd6_7b in_act slb6_7 vs6 sldrv
Cs6_7a sl6_7 0 1e-16
Cs6_7b slb6_7 0 1e-16
Xc6_7 sl6_7 slb6_7 ml6_7 0 0 tcam2f dvgl=0 dvgr=0 xl1=1 xl2=1 xl3=1 xl4=1 xl5=1 xl6=1
+ xl7=1 xl8=1 xl9=1 xl10=1 xl11=1 xl12=1 xl13=1 xl14=0.999999988
+ xl15=1.00000021 xl16=0.999959662 xr1=-1 xr2=-1 xr3=-1 xr4=-1 xr5=-1 xr6=-1
+ xr7=-1 xr8=-1 xr9=-1 xr10=-1 xr11=-1 xr12=-1 xr13=-1 xr14=-1
+ xr15=-1 xr16=-1
.ic v(xc6_7.xl.m)=0.424804359 v(xc6_7.xr.m)=-0.277154442
Cm6_7 ml6_7 0 1e-16
Xp6 ml6_0 preb vdd6 mlpre
Xsa6 ml6_0 miss6 match6 vdd6 mlsa
.ic v(ml6_0)=1.0 v(ml6_1)=1.0 v(ml6_2)=1.0 v(ml6_3)=1.0 v(ml6_4)=1.0 v(ml6_5)=1.0 v(ml6_6)=1.0 v(ml6_7)=1.0 v(match6)=1.0
* word 7: stored 10110100 key 01001010 -> 7 mismatch(es)
Vdd7 vdd7 0 1.0
Vs7 vs7 0 1.1
Xd7_0a vs7 sl7_0 vs7 sldrv
Xd7_0b in_act slb7_0 vs7 sldrv
Cs7_0a sl7_0 0 1e-16
Cs7_0b slb7_0 0 1e-16
Xc7_0 sl7_0 slb7_0 ml7_0 0 0 tcam2f dvgl=0 dvgr=0 xl1=-1 xl2=-1 xl3=-1 xl4=-1 xl5=-1 xl6=-1
+ xl7=-1 xl8=-1 xl9=-1 xl10=-1 xl11=-1 xl12=-1 xl13=-1 xl14=-1
+ xl15=-1 xl16=-1 xr1=1 xr2=1 xr3=1 xr4=1 xr5=1 xr6=1
+ xr7=1 xr8=1 xr9=1 xr10=1 xr11=1 xr12=1 xr13=1 xr14=0.999999988
+ xr15=1.00000021 xr16=0.999959662
.ic v(xc7_0.xl.m)=-0.277154442 v(xc7_0.xr.m)=0.424804359
Cm7_0 ml7_0 0 1e-16
Rm7_0 ml7_0 ml7_1 3.2
Xd7_1a in_act sl7_1 vs7 sldrv
Xd7_1b vs7 slb7_1 vs7 sldrv
Cs7_1a sl7_1 0 1e-16
Cs7_1b slb7_1 0 1e-16
Xc7_1 sl7_1 slb7_1 ml7_1 0 0 tcam2f dvgl=0 dvgr=0 xl1=1 xl2=1 xl3=1 xl4=1 xl5=1 xl6=1
+ xl7=1 xl8=1 xl9=1 xl10=1 xl11=1 xl12=1 xl13=1 xl14=0.999999988
+ xl15=1.00000021 xl16=0.999959662 xr1=-1 xr2=-1 xr3=-1 xr4=-1 xr5=-1 xr6=-1
+ xr7=-1 xr8=-1 xr9=-1 xr10=-1 xr11=-1 xr12=-1 xr13=-1 xr14=-1
+ xr15=-1 xr16=-1
.ic v(xc7_1.xl.m)=0.424804359 v(xc7_1.xr.m)=-0.277154442
Cm7_1 ml7_1 0 1e-16
Rm7_1 ml7_1 ml7_2 3.2
Xd7_2a vs7 sl7_2 vs7 sldrv
Xd7_2b in_act slb7_2 vs7 sldrv
Cs7_2a sl7_2 0 1e-16
Cs7_2b slb7_2 0 1e-16
Xc7_2 sl7_2 slb7_2 ml7_2 0 0 tcam2f dvgl=0 dvgr=0 xl1=-1 xl2=-1 xl3=-1 xl4=-1 xl5=-1 xl6=-1
+ xl7=-1 xl8=-1 xl9=-1 xl10=-1 xl11=-1 xl12=-1 xl13=-1 xl14=-1
+ xl15=-1 xl16=-1 xr1=1 xr2=1 xr3=1 xr4=1 xr5=1 xr6=1
+ xr7=1 xr8=1 xr9=1 xr10=1 xr11=1 xr12=1 xr13=1 xr14=0.999999988
+ xr15=1.00000021 xr16=0.999959662
.ic v(xc7_2.xl.m)=-0.277154442 v(xc7_2.xr.m)=0.424804359
Cm7_2 ml7_2 0 1e-16
Rm7_2 ml7_2 ml7_3 3.2
Xd7_3a vs7 sl7_3 vs7 sldrv
Xd7_3b in_act slb7_3 vs7 sldrv
Cs7_3a sl7_3 0 1e-16
Cs7_3b slb7_3 0 1e-16
Xc7_3 sl7_3 slb7_3 ml7_3 0 0 tcam2f dvgl=0 dvgr=0 xl1=-1 xl2=-1 xl3=-1 xl4=-1 xl5=-1 xl6=-1
+ xl7=-1 xl8=-1 xl9=-1 xl10=-1 xl11=-1 xl12=-1 xl13=-1 xl14=-1
+ xl15=-1 xl16=-1 xr1=1 xr2=1 xr3=1 xr4=1 xr5=1 xr6=1
+ xr7=1 xr8=1 xr9=1 xr10=1 xr11=1 xr12=1 xr13=1 xr14=0.999999988
+ xr15=1.00000021 xr16=0.999959662
.ic v(xc7_3.xl.m)=-0.277154442 v(xc7_3.xr.m)=0.424804359
Cm7_3 ml7_3 0 1e-16
Rm7_3 ml7_3 ml7_4 3.2
Xd7_4a in_act sl7_4 vs7 sldrv
Xd7_4b vs7 slb7_4 vs7 sldrv
Cs7_4a sl7_4 0 1e-16
Cs7_4b slb7_4 0 1e-16
Xc7_4 sl7_4 slb7_4 ml7_4 0 0 tcam2f dvgl=0 dvgr=0 xl1=1 xl2=1 xl3=1 xl4=1 xl5=1 xl6=1
+ xl7=1 xl8=1 xl9=1 xl10=1 xl11=1 xl12=1 xl13=1 xl14=0.999999988
+ xl15=1.00000021 xl16=0.999959662 xr1=-1 xr2=-1 xr3=-1 xr4=-1 xr5=-1 xr6=-1
+ xr7=-1 xr8=-1 xr9=-1 xr10=-1 xr11=-1 xr12=-1 xr13=-1 xr14=-1
+ xr15=-1 xr16=-1
.ic v(xc7_4.xl.m)=0.424804359 v(xc7_4.xr.m)=-0.277154442
Cm7_4 ml7_4 0 1e-16
Rm7_4 ml7_4 ml7_5 3.2
Xd7_5a vs7 sl7_5 vs7 sldrv
Xd7_5b in_act slb7_5 vs7 sldrv
Cs7_5a sl7_5 0 1e-16
Cs7_5b slb7_5 0 1e-16
Xc7_5 sl7_5 slb7_5 ml7_5 0 0 tcam2f dvgl=0 dvgr=0 xl1=-1 xl2=-1 xl3=-1 xl4=-1 xl5=-1 xl6=-1
+ xl7=-1 xl8=-1 xl9=-1 xl10=-1 xl11=-1 xl12=-1 xl13=-1 xl14=-1
+ xl15=-1 xl16=-1 xr1=1 xr2=1 xr3=1 xr4=1 xr5=1 xr6=1
+ xr7=1 xr8=1 xr9=1 xr10=1 xr11=1 xr12=1 xr13=1 xr14=0.999999988
+ xr15=1.00000021 xr16=0.999959662
.ic v(xc7_5.xl.m)=-0.277154442 v(xc7_5.xr.m)=0.424804359
Cm7_5 ml7_5 0 1e-16
Rm7_5 ml7_5 ml7_6 3.2
Xd7_6a in_act sl7_6 vs7 sldrv
Xd7_6b vs7 slb7_6 vs7 sldrv
Cs7_6a sl7_6 0 1e-16
Cs7_6b slb7_6 0 1e-16
Xc7_6 sl7_6 slb7_6 ml7_6 0 0 tcam2f dvgl=0 dvgr=0 xl1=1 xl2=1 xl3=1 xl4=1 xl5=1 xl6=1
+ xl7=1 xl8=1 xl9=1 xl10=1 xl11=1 xl12=1 xl13=1 xl14=0.999999988
+ xl15=1.00000021 xl16=0.999959662 xr1=-1 xr2=-1 xr3=-1 xr4=-1 xr5=-1 xr6=-1
+ xr7=-1 xr8=-1 xr9=-1 xr10=-1 xr11=-1 xr12=-1 xr13=-1 xr14=-1
+ xr15=-1 xr16=-1
.ic v(xc7_6.xl.m)=0.424804359 v(xc7_6.xr.m)=-0.277154442
Cm7_6 ml7_6 0 1e-16
Rm7_6 ml7_6 ml7_7 3.2
Xd7_7a vs7 sl7_7 vs7 sldrv
Xd7_7b in_act slb7_7 vs7 sldrv
Cs7_7a sl7_7 0 1e-16
Cs7_7b slb7_7 0 1e-16
Xc7_7 sl7_7 slb7_7 ml7_7 0 0 tcam2f dvgl=0 dvgr=0 xl1=1 xl2=1 xl3=1 xl4=1 xl5=1 xl6=1
+ xl7=1 xl8=1 xl9=1 xl10=1 xl11=1 xl12=1 xl13=1 xl14=0.999999988
+ xl15=1.00000021 xl16=0.999959662 xr1=-1 xr2=-1 xr3=-1 xr4=-1 xr5=-1 xr6=-1
+ xr7=-1 xr8=-1 xr9=-1 xr10=-1 xr11=-1 xr12=-1 xr13=-1 xr14=-1
+ xr15=-1 xr16=-1
.ic v(xc7_7.xl.m)=0.424804359 v(xc7_7.xr.m)=-0.277154442
Cm7_7 ml7_7 0 1e-16
Xp7 ml7_0 preb vdd7 mlpre
Xsa7 ml7_0 miss7 match7 vdd7 mlsa
.ic v(ml7_0)=1.0 v(ml7_1)=1.0 v(ml7_2)=1.0 v(ml7_3)=1.0 v(ml7_4)=1.0 v(ml7_5)=1.0 v(ml7_6)=1.0 v(ml7_7)=1.0 v(match7)=1.0
* word 8: stored 10110100 key 01001011 -> 8 mismatch(es)
Vdd8 vdd8 0 1.0
Vs8 vs8 0 1.1
Xd8_0a vs8 sl8_0 vs8 sldrv
Xd8_0b in_act slb8_0 vs8 sldrv
Cs8_0a sl8_0 0 1e-16
Cs8_0b slb8_0 0 1e-16
Xc8_0 sl8_0 slb8_0 ml8_0 0 0 tcam2f dvgl=0 dvgr=0 xl1=-1 xl2=-1 xl3=-1 xl4=-1 xl5=-1 xl6=-1
+ xl7=-1 xl8=-1 xl9=-1 xl10=-1 xl11=-1 xl12=-1 xl13=-1 xl14=-1
+ xl15=-1 xl16=-1 xr1=1 xr2=1 xr3=1 xr4=1 xr5=1 xr6=1
+ xr7=1 xr8=1 xr9=1 xr10=1 xr11=1 xr12=1 xr13=1 xr14=0.999999988
+ xr15=1.00000021 xr16=0.999959662
.ic v(xc8_0.xl.m)=-0.277154442 v(xc8_0.xr.m)=0.424804359
Cm8_0 ml8_0 0 1e-16
Rm8_0 ml8_0 ml8_1 3.2
Xd8_1a in_act sl8_1 vs8 sldrv
Xd8_1b vs8 slb8_1 vs8 sldrv
Cs8_1a sl8_1 0 1e-16
Cs8_1b slb8_1 0 1e-16
Xc8_1 sl8_1 slb8_1 ml8_1 0 0 tcam2f dvgl=0 dvgr=0 xl1=1 xl2=1 xl3=1 xl4=1 xl5=1 xl6=1
+ xl7=1 xl8=1 xl9=1 xl10=1 xl11=1 xl12=1 xl13=1 xl14=0.999999988
+ xl15=1.00000021 xl16=0.999959662 xr1=-1 xr2=-1 xr3=-1 xr4=-1 xr5=-1 xr6=-1
+ xr7=-1 xr8=-1 xr9=-1 xr10=-1 xr11=-1 xr12=-1 xr13=-1 xr14=-1
+ xr15=-1 xr16=-1
.ic v(xc8_1.xl.m)=0.424804359 v(xc8_1.xr.m)=-0.277154442
Cm8_1 ml8_1 0 1e-16
Rm8_1 ml8_1 ml8_2 3.2
Xd8_2a vs8 sl8_2 vs8 sldrv
Xd8_2b in_act slb8_2 vs8 sldrv
Cs8_2a sl8_2 0 1e-16
Cs8_2b slb8_2 0 1e-16
Xc8_2 sl8_2 slb8_2 ml8_2 0 0 tcam2f dvgl=0 dvgr=0 xl1=-1 xl2=-1 xl3=-1 xl4=-1 xl5=-1 xl6=-1
+ xl7=-1 xl8=-1 xl9=-1 xl10=-1 xl11=-1 xl12=-1 xl13=-1 xl14=-1
+ xl15=-1 xl16=-1 xr1=1 xr2=1 xr3=1 xr4=1 xr5=1 xr6=1
+ xr7=1 xr8=1 xr9=1 xr10=1 xr11=1 xr12=1 xr13=1 xr14=0.999999988
+ xr15=1.00000021 xr16=0.999959662
.ic v(xc8_2.xl.m)=-0.277154442 v(xc8_2.xr.m)=0.424804359
Cm8_2 ml8_2 0 1e-16
Rm8_2 ml8_2 ml8_3 3.2
Xd8_3a vs8 sl8_3 vs8 sldrv
Xd8_3b in_act slb8_3 vs8 sldrv
Cs8_3a sl8_3 0 1e-16
Cs8_3b slb8_3 0 1e-16
Xc8_3 sl8_3 slb8_3 ml8_3 0 0 tcam2f dvgl=0 dvgr=0 xl1=-1 xl2=-1 xl3=-1 xl4=-1 xl5=-1 xl6=-1
+ xl7=-1 xl8=-1 xl9=-1 xl10=-1 xl11=-1 xl12=-1 xl13=-1 xl14=-1
+ xl15=-1 xl16=-1 xr1=1 xr2=1 xr3=1 xr4=1 xr5=1 xr6=1
+ xr7=1 xr8=1 xr9=1 xr10=1 xr11=1 xr12=1 xr13=1 xr14=0.999999988
+ xr15=1.00000021 xr16=0.999959662
.ic v(xc8_3.xl.m)=-0.277154442 v(xc8_3.xr.m)=0.424804359
Cm8_3 ml8_3 0 1e-16
Rm8_3 ml8_3 ml8_4 3.2
Xd8_4a in_act sl8_4 vs8 sldrv
Xd8_4b vs8 slb8_4 vs8 sldrv
Cs8_4a sl8_4 0 1e-16
Cs8_4b slb8_4 0 1e-16
Xc8_4 sl8_4 slb8_4 ml8_4 0 0 tcam2f dvgl=0 dvgr=0 xl1=1 xl2=1 xl3=1 xl4=1 xl5=1 xl6=1
+ xl7=1 xl8=1 xl9=1 xl10=1 xl11=1 xl12=1 xl13=1 xl14=0.999999988
+ xl15=1.00000021 xl16=0.999959662 xr1=-1 xr2=-1 xr3=-1 xr4=-1 xr5=-1 xr6=-1
+ xr7=-1 xr8=-1 xr9=-1 xr10=-1 xr11=-1 xr12=-1 xr13=-1 xr14=-1
+ xr15=-1 xr16=-1
.ic v(xc8_4.xl.m)=0.424804359 v(xc8_4.xr.m)=-0.277154442
Cm8_4 ml8_4 0 1e-16
Rm8_4 ml8_4 ml8_5 3.2
Xd8_5a vs8 sl8_5 vs8 sldrv
Xd8_5b in_act slb8_5 vs8 sldrv
Cs8_5a sl8_5 0 1e-16
Cs8_5b slb8_5 0 1e-16
Xc8_5 sl8_5 slb8_5 ml8_5 0 0 tcam2f dvgl=0 dvgr=0 xl1=-1 xl2=-1 xl3=-1 xl4=-1 xl5=-1 xl6=-1
+ xl7=-1 xl8=-1 xl9=-1 xl10=-1 xl11=-1 xl12=-1 xl13=-1 xl14=-1
+ xl15=-1 xl16=-1 xr1=1 xr2=1 xr3=1 xr4=1 xr5=1 xr6=1
+ xr7=1 xr8=1 xr9=1 xr10=1 xr11=1 xr12=1 xr13=1 xr14=0.999999988
+ xr15=1.00000021 xr16=0.999959662
.ic v(xc8_5.xl.m)=-0.277154442 v(xc8_5.xr.m)=0.424804359
Cm8_5 ml8_5 0 1e-16
Rm8_5 ml8_5 ml8_6 3.2
Xd8_6a in_act sl8_6 vs8 sldrv
Xd8_6b vs8 slb8_6 vs8 sldrv
Cs8_6a sl8_6 0 1e-16
Cs8_6b slb8_6 0 1e-16
Xc8_6 sl8_6 slb8_6 ml8_6 0 0 tcam2f dvgl=0 dvgr=0 xl1=1 xl2=1 xl3=1 xl4=1 xl5=1 xl6=1
+ xl7=1 xl8=1 xl9=1 xl10=1 xl11=1 xl12=1 xl13=1 xl14=0.999999988
+ xl15=1.00000021 xl16=0.999959662 xr1=-1 xr2=-1 xr3=-1 xr4=-1 xr5=-1 xr6=-1
+ xr7=-1 xr8=-1 xr9=-1 xr10=-1 xr11=-1 xr12=-1 xr13=-1 xr14=-1
+ xr15=-1 xr16=-1
.ic v(xc8_6.xl.m)=0.424804359 v(xc8_6.xr.m)=-0.277154442
Cm8_6 ml8_6 0 1e-16
Rm8_6 ml8_6 ml8_7 3.2
Xd8_7a in_act sl8_7 vs8 sldrv
Xd8_7b vs8 slb8_7 vs8 sldrv
Cs8_7a sl8_7 0 1e-16
Cs8_7b slb8_7 0 1e-16
Xc8_7 sl8_7 slb8_7 ml8_7 0 0 tcam2f dvgl=0 dvgr=0 xl1=1 xl2=1 xl3=1 xl4=1 xl5=1 xl6=1
+ xl7=1 xl8=1 xl9=1 xl10=1 xl11=1 xl12=1 xl13=1 xl14=0.999999988
+ xl15=1.00000021 xl16=0.999959662 xr1=-1 xr2=-1 xr3=-1 xr4=-1 xr5=-1 xr6=-1
+ xr7=-1 xr8=-1 xr9=-1 xr10=-1 xr11=-1 xr12=-1 xr13=-1 xr14=-1
+ xr15=-1 xr16=-1
.ic v(xc8_7.xl.m)=0.424804359 v(xc8_7.xr.m)=-0.277154442
Cm8_7 ml8_7 0 1e-16
Xp8 ml8_0 preb vdd8 mlpre
Xsa8 ml8_0 miss8 match8 vdd8 mlsa
.ic v(ml8_0)=1.0 v(ml8_1)=1.0 v(ml8_2)=1.0 v(ml8_3)=1.0 v(ml8_4)=1.0 v(ml8_5)=1.0 v(ml8_6)=1.0 v(ml8_7)=1.0 v(match8)=1.0
* word 9: stored 11110000 key XX000000 -> 2 mismatch(es)
Vdd9 vdd9 0 1.0
Vs9 vs9 0 1.1
Xd9_0a vs9 sl9_0 vs9 sldrv
Xd9_0b vs9 slb9_0 vs9 sldrv
Cs9_0a sl9_0 0 1e-16
Cs9_0b slb9_0 0 1e-16
Xc9_0 sl9_0 slb9_0 ml9_0 0 0 tcam2f dvgl=0 dvgr=0 xl1=-1 xl2=-1 xl3=-1 xl4=-1 xl5=-1 xl6=-1
+ xl7=-1 xl8=-1 xl9=-1 xl10=-1 xl11=-1 xl12=-1 xl13=-1 xl14=-1
+ xl15=-1 xl16=-1 xr1=1 xr2=1 xr3=1 xr4=1 xr5=1 xr6=1
+ xr7=1 xr8=1 xr9=1 xr10=1 xr11=1 xr12=1 xr13=1 xr14=0.999999988
+ xr15=1.00000021 xr16=0.999959662
.ic v(xc9_0.xl.m)=-0.277154442 v(xc9_0.xr.m)=0.424804359
Cm9_0 ml9_0 0 1e-16
Rm9_0 ml9_0 ml9_1 3.2
Xd9_1a vs9 sl9_1 vs9 sldrv
Xd9_1b vs9 slb9_1 vs9 sldrv
Cs9_1a sl9_1 0 1e-16
Cs9_1b slb9_1 0 1e-16
Xc9_1 sl9_1 slb9_1 ml9_1 0 0 tcam2f dvgl=0 dvgr=0 xl1=-1 xl2=-1 xl3=-1 xl4=-1 xl5=-1 xl6=-1
+ xl7=-1 xl8=-1 xl9=-1 xl10=-1 xl11=-1 xl12=-1 xl13=-1 xl14=-1
+ xl15=-1 xl16=-1 xr1=1 xr2=1 xr3=1 xr4=1 xr5=1 xr6=1
+ xr7=1 xr8=1 xr9=1 xr10=1 xr11=1 xr12=1 xr13=1 xr14=0.999999988
+ xr15=1.00000021 xr16=0.999959662
.ic v(xc9_1.xl.m)=-0.277154442 v(xc9_1.xr.m)=0.424804359
Cm9_1 ml9_1 0 1e-16
Rm9_1 ml9_1 ml9_2 3.2
Xd9_2a vs9 sl9_2 vs9 sldrv
Xd9_2b in_act slb9_2 vs9 sldrv
Cs9_2a sl9_2 0 1e-16
Cs9_2b slb9_2 0 1e-16
Xc9_2 sl9_2 slb9_2 ml9_2 0 0 tcam2f dvgl=0 dvgr=0 xl1=-1 xl2=-1 xl3=-1 xl4=-1 xl5=-1 xl6=-1
+ xl7=-1 xl8=-1 xl9=-1 xl10=-1 xl11=-1 xl12=-1 xl13=-1 xl14=-1
+ xl15=-1 xl16=-1 xr1=1 xr2=1 xr3=1 xr4=1 xr5=1 xr6=1
+ xr7=1 xr8=1 xr9=1 xr10=1 xr11=1 xr12=1 xr13=1 xr14=0.999999988
+ xr15=1.00000021 xr16=0.999959662
.ic v(xc9_2.xl.m)=-0.277154442 v(xc9_2.xr.m)=0.424804359
Cm9_2 ml9_2 0 1e-16
Rm9_2 ml9_2 ml9_3 3.2
Xd9_3a vs9 sl9_3 vs9 sldrv
Xd9_3b in_act slb9_3 vs9 sldrv
Cs9_3a sl9_3 0 1e-16
Cs9_3b slb9_3 0 1e-16
Xc9_3 sl9_3 slb9_3 ml9_3 0 0 tcam2f dvgl=0 dvgr=0 xl1=-1 xl2=-1 xl3=-1 xl4=-1 xl5=-1 xl6=-1
+ xl7=-1 xl8=-1 xl9=-1 xl10=-1 xl11=-1 xl12=-1 xl13=-1 xl14=-1
+ xl15=-1 xl16=-1 xr1=1 xr2=1 xr3=1 xr4=1 xr5=1 xr6=1
+ xr7=1 xr8=1 xr9=1 xr10=1 xr11=1 xr12=1 xr13=1 xr14=0.999999988
+ xr15=1.00000021 xr16=0.999959662
.ic v(xc9_3.xl.m)=-0.277154442 v(xc9_3.xr.m)=0.424804359
Cm9_3 ml9_3 0 1e-16
Rm9_3 ml9_3 ml9_4 3.2
Xd9_4a vs9 sl9_4 vs9 sldrv
Xd9_4b in_act slb9_4 vs9 sldrv
Cs9_4a sl9_4 0 1e-16
Cs9_4b slb9_4 0 1e-16
Xc9_4 sl9_4 slb9_4 ml9_4 0 0 tcam2f dvgl=0 dvgr=0 xl1=1 xl2=1 xl3=1 xl4=1 xl5=1 xl6=1
+ xl7=1 xl8=1 xl9=1 xl10=1 xl11=1 xl12=1 xl13=1 xl14=0.999999988
+ xl15=1.00000021 xl16=0.999959662 xr1=-1 xr2=-1 xr3=-1 xr4=-1 xr5=-1 xr6=-1
+ xr7=-1 xr8=-1 xr9=-1 xr10=-1 xr11=-1 xr12=-1 xr13=-1 xr14=-1
+ xr15=-1 xr16=-1
.ic v(xc9_4.xl.m)=0.424804359 v(xc9_4.xr.m)=-0.277154442
Cm9_4 ml9_4 0 1e-16
Rm9_4 ml9_4 ml9_5 3.2
Xd9_5a vs9 sl9_5 vs9 sldrv
Xd9_5b in_act slb9_5 vs9 sldrv
Cs9_5a sl9_5 0 1e-16
Cs9_5b slb9_5 0 1e-16
Xc9_5 sl9_5 slb9_5 ml9_5 0 0 tcam2f dvgl=0 dvgr=0 xl1=1 xl2=1 xl3=1 xl4=1 xl5=1 xl6=1
+ xl7=1 xl8=1 xl9=1 xl10=1 xl11=1 xl12=1 xl13=1 xl14=0.999999988
+ xl15=1.00000021 xl16=0.999959662 xr1=-1 xr2=-1 xr3=-1 xr4=-1 xr5=-1 xr6=-1
+ xr7=-1 xr8=-1 xr9=-1 xr10=-1 xr11=-1 xr12=-1 xr13=-1 xr14=-1
+ xr15=-1 xr16=-1
.ic v(xc9_5.xl.m)=0.424804359 v(xc9_5.xr.m)=-0.277154442
Cm9_5 ml9_5 0 1e-16
Rm9_5 ml9_5 ml9_6 3.2
Xd9_6a vs9 sl9_6 vs9 sldrv
Xd9_6b in_act slb9_6 vs9 sldrv
Cs9_6a sl9_6 0 1e-16
Cs9_6b slb9_6 0 1e-16
Xc9_6 sl9_6 slb9_6 ml9_6 0 0 tcam2f dvgl=0 dvgr=0 xl1=1 xl2=1 xl3=1 xl4=1 xl5=1 xl6=1
+ xl7=1 xl8=1 xl9=1 xl10=1 xl11=1 xl12=1 xl13=1 xl14=0.999999988
+ xl15=1.00000021 xl16=0.999959662 xr1=-1 xr2=-1 xr3=-1 xr4=-1 xr5=-1 xr6=-1
+ xr7=-1 xr8=-1 xr9=-1 xr10=-1 xr11=-1 xr12=-1 xr13=-1 xr14=-1
+ xr15=-1 xr16=-1
.ic v(xc9_6.xl.m)=0.424804359 v(xc9_6.xr.m)=-0.277154442
Cm9_6 ml9_6 0 1e-16
Rm9_6 ml9_6 ml9_7 3.2
Xd9_7a vs9 sl9_7 vs9 sldrv
Xd9_7b in_act slb9_7 vs9 sldrv
Cs9_7a sl9_7 0 1e-16
Cs9_7b slb9_7 0 1e-16
Xc9_7 sl9_7 slb9_7 ml9_7 0 0 tcam2f dvgl=0 dvgr=0 xl1=1 xl2=1 xl3=1 xl4=1 xl5=1 xl6=1
+ xl7=1 xl8=1 xl9=1 xl10=1 xl11=1 xl12=1 xl13=1 xl14=0.999999988
+ xl15=1.00000021 xl16=0.999959662 xr1=-1 xr2=-1 xr3=-1 xr4=-1 xr5=-1 xr6=-1
+ xr7=-1 xr8=-1 xr9=-1 xr10=-1 xr11=-1 xr12=-1 xr13=-1 xr14=-1
+ xr15=-1 xr16=-1
.ic v(xc9_7.xl.m)=0.424804359 v(xc9_7.xr.m)=-0.277154442
Cm9_7 ml9_7 0 1e-16
Xp9 ml9_0 preb vdd9 mlpre
Xsa9 ml9_0 miss9 match9 vdd9 mlsa
.ic v(ml9_0)=1.0 v(ml9_1)=1.0 v(ml9_2)=1.0 v(ml9_3)=1.0 v(ml9_4)=1.0 v(ml9_5)=1.0 v(ml9_6)=1.0 v(ml9_7)=1.0 v(match9)=1.0
* word 10: stored 11110000 key XXXXXXXX -> 0 mismatch(es)
Vdd10 vdd10 0 1.0
Vs10 vs10 0 1.1
Xd10_0a vs10 sl10_0 vs10 sldrv
Xd10_0b vs10 slb10_0 vs10 sldrv
Cs10_0a sl10_0 0 1e-16
Cs10_0b slb10_0 0 1e-16
Xc10_0 sl10_0 slb10_0 ml10_0 0 0 tcam2f dvgl=0 dvgr=0 xl1=-1 xl2=-1 xl3=-1 xl4=-1 xl5=-1 xl6=-1
+ xl7=-1 xl8=-1 xl9=-1 xl10=-1 xl11=-1 xl12=-1 xl13=-1 xl14=-1
+ xl15=-1 xl16=-1 xr1=1 xr2=1 xr3=1 xr4=1 xr5=1 xr6=1
+ xr7=1 xr8=1 xr9=1 xr10=1 xr11=1 xr12=1 xr13=1 xr14=0.999999988
+ xr15=1.00000021 xr16=0.999959662
.ic v(xc10_0.xl.m)=-0.277154442 v(xc10_0.xr.m)=0.424804359
Cm10_0 ml10_0 0 1e-16
Rm10_0 ml10_0 ml10_1 3.2
Xd10_1a vs10 sl10_1 vs10 sldrv
Xd10_1b vs10 slb10_1 vs10 sldrv
Cs10_1a sl10_1 0 1e-16
Cs10_1b slb10_1 0 1e-16
Xc10_1 sl10_1 slb10_1 ml10_1 0 0 tcam2f dvgl=0 dvgr=0 xl1=-1 xl2=-1 xl3=-1 xl4=-1 xl5=-1 xl6=-1
+ xl7=-1 xl8=-1 xl9=-1 xl10=-1 xl11=-1 xl12=-1 xl13=-1 xl14=-1
+ xl15=-1 xl16=-1 xr1=1 xr2=1 xr3=1 xr4=1 xr5=1 xr6=1
+ xr7=1 xr8=1 xr9=1 xr10=1 xr11=1 xr12=1 xr13=1 xr14=0.999999988
+ xr15=1.00000021 xr16=0.999959662
.ic v(xc10_1.xl.m)=-0.277154442 v(xc10_1.xr.m)=0.424804359
Cm10_1 ml10_1 0 1e-16
Rm10_1 ml10_1 ml10_2 3.2
Xd10_2a vs10 sl10_2 vs10 sldrv
Xd10_2b vs10 slb10_2 vs10 sldrv
Cs10_2a sl10_2 0 1e-16
Cs10_2b slb10_2 0 1e-16
Xc10_2 sl10_2 slb10_2 ml10_2 0 0 tcam2f dvgl=0 dvgr=0 xl1=-1 xl2=-1 xl3=-1 xl4=-1 xl5=-1 xl6=-1
+ xl7=-1 xl8=-1 xl9=-1 xl10=-1 xl11=-1 xl12=-1 xl13=-1 xl14=-1
+ xl15=-1 xl16=-1 xr1=1 xr2=1 xr3=1 xr4=1 xr5=1 xr6=1
+ xr7=1 xr8=1 xr9=1 xr10=1 xr11=1 xr12=1 xr13=1 xr14=0.999999988
+ xr15=1.00000021 xr16=0.999959662
.ic v(xc10_2.xl.m)=-0.277154442 v(xc10_2.xr.m)=0.424804359
Cm10_2 ml10_2 0 1e-16
Rm10_2 ml10_2 ml10_3 3.2
Xd10_3a vs10 sl10_3 vs10 sldrv
Xd10_3b vs10 slb10_3 vs10 sldrv
Cs10_3a sl10_3 0 1e-16
Cs10_3b slb10_3 0 1e-16
Xc10_3 sl10_3 slb10_3 ml10_3 0 0 tcam2f dvgl=0 dvgr=0 xl1=-1 xl2=-1 xl3=-1 xl4=-1 xl5=-1 xl6=-1
+ xl7=-1 xl8=-1 xl9=-1 xl10=-1 xl11=-1 xl12=-1 xl13=-1 xl14=-1
+ xl15=-1 xl16=-1 xr1=1 xr2=1 xr3=1 xr4=1 xr5=1 xr6=1
+ xr7=1 xr8=1 xr9=1 xr10=1 xr11=1 xr12=1 xr13=1 xr14=0.999999988
+ xr15=1.00000021 xr16=0.999959662
.ic v(xc10_3.xl.m)=-0.277154442 v(xc10_3.xr.m)=0.424804359
Cm10_3 ml10_3 0 1e-16
Rm10_3 ml10_3 ml10_4 3.2
Xd10_4a vs10 sl10_4 vs10 sldrv
Xd10_4b vs10 slb10_4 vs10 sldrv
Cs10_4a sl10_4 0 1e-16
Cs10_4b slb10_4 0 1e-16
Xc10_4 sl10_4 slb10_4 ml10_4 0 0 tcam2f dvgl=0 dvgr=0 xl1=1 xl2=1 xl3=1 xl4=1 xl5=1 xl6=1
+ xl7=1 xl8=1 xl9=1 xl10=1 xl11=1 xl12=1 xl13=1 xl14=0.999999988
+ xl15=1.00000021 xl16=0.999959662 xr1=-1 xr2=-1 xr3=-1 xr4=-1 xr5=-1 xr6=-1
+ xr7=-1 xr8=-1 xr9=-1 xr10=-1 xr11=-1 xr12=-1 xr13=-1 xr14=-1
+ xr15=-1 xr16=-1
.ic v(xc10_4.xl.m)=0.424804359 v(xc10_4.xr.m)=-0.277154442
Cm10_4 ml10_4 0 1e-16
Rm10_4 ml10_4 ml10_5 3.2
Xd10_5a vs10 sl10_5 vs10 sldrv
Xd10_5b vs10 slb10_5 vs10 sldrv
Cs10_5a sl10_5 0 1e-16
Cs10_5b slb10_5 0 1e-16
Xc10_5 sl10_5 slb10_5 ml10_5 0 0 tcam2f dvgl=0 dvgr=0 xl1=1 xl2=1 xl3=1 xl4=1 xl5=1 xl6=1
+ xl7=1 xl8=1 xl9=1 xl10=1 xl11=1 xl12=1 xl13=1 xl14=0.999999988
+ xl15=1.00000021 xl16=0.999959662 xr1=-1 xr2=-1 xr3=-1 xr4=-1 xr5=-1 xr6=-1
+ xr7=-1 xr8=-1 xr9=-1 xr10=-1 xr11=-1 xr12=-1 xr13=-1 xr14=-1
+ xr15=-1 xr16=-1
.ic v(xc10_5.xl.m)=0.424804359 v(xc10_5.xr.m)=-0.277154442
Cm10_5 ml10_5 0 1e-16
Rm10_5 ml10_5 ml10_6 3.2
Xd10_6a vs10 sl10_6 vs10 sldrv
Xd10_6b vs10 slb10_6 vs10 sldrv
Cs10_6a sl10_6 0 1e-16
Cs10_6b slb10_6 0 1e-16
Xc10_6 sl10_6 slb10_6 ml10_6 0 0 tcam2f dvgl=0 dvgr=0 xl1=1 xl2=1 xl3=1 xl4=1 xl5=1 xl6=1
+ xl7=1 xl8=1 xl9=1 xl10=1 xl11=1 xl12=1 xl13=1 xl14=0.999999988
+ xl15=1.00000021 xl16=0.999959662 xr1=-1 xr2=-1 xr3=-1 xr4=-1 xr5=-1 xr6=-1
+ xr7=-1 xr8=-1 xr9=-1 xr10=-1 xr11=-1 xr12=-1 xr13=-1 xr14=-1
+ xr15=-1 xr16=-1
.ic v(xc10_6.xl.m)=0.424804359 v(xc10_6.xr.m)=-0.277154442
Cm10_6 ml10_6 0 1e-16
Rm10_6 ml10_6 ml10_7 3.2
Xd10_7a vs10 sl10_7 vs10 sldrv
Xd10_7b vs10 slb10_7 vs10 sldrv
Cs10_7a sl10_7 0 1e-16
Cs10_7b slb10_7 0 1e-16
Xc10_7 sl10_7 slb10_7 ml10_7 0 0 tcam2f dvgl=0 dvgr=0 xl1=1 xl2=1 xl3=1 xl4=1 xl5=1 xl6=1
+ xl7=1 xl8=1 xl9=1 xl10=1 xl11=1 xl12=1 xl13=1 xl14=0.999999988
+ xl15=1.00000021 xl16=0.999959662 xr1=-1 xr2=-1 xr3=-1 xr4=-1 xr5=-1 xr6=-1
+ xr7=-1 xr8=-1 xr9=-1 xr10=-1 xr11=-1 xr12=-1 xr13=-1 xr14=-1
+ xr15=-1 xr16=-1
.ic v(xc10_7.xl.m)=0.424804359 v(xc10_7.xr.m)=-0.277154442
Cm10_7 ml10_7 0 1e-16
Xp10 ml10_0 preb vdd10 mlpre
Xsa10 ml10_0 miss10 match10 vdd10 mlsa
.ic v(ml10_0)=1.0 v(ml10_1)=1.0 v(ml10_2)=1.0 v(ml10_3)=1.0 v(ml10_4)=1.0 v(ml10_5)=1.0 v(ml10_6)=1.0 v(ml10_7)=1.0 v(match10)=1.0
* word 11: stored 11110000 key 00000000 -> 4 mismatch(es)
Vdd11 vdd11 0 1.0
Vs11 vs11 0 1.1
Xd11_0a vs11 sl11_0 vs11 sldrv
Xd11_0b in_act slb11_0 vs11 sldrv
Cs11_0a sl11_0 0 1e-16
Cs11_0b slb11_0 0 1e-16
Xc11_0 sl11_0 slb11_0 ml11_0 0 0 tcam2f dvgl=0 dvgr=0 xl1=-1 xl2=-1 xl3=-1 xl4=-1 xl5=-1 xl6=-1
+ xl7=-1 xl8=-1 xl9=-1 xl10=-1 xl11=-1 xl12=-1 xl13=-1 xl14=-1
+ xl15=-1 xl16=-1 xr1=1 xr2=1 xr3=1 xr4=1 xr5=1 xr6=1
+ xr7=1 xr8=1 xr9=1 xr10=1 xr11=1 xr12=1 xr13=1 xr14=0.999999988
+ xr15=1.00000021 xr16=0.999959662
.ic v(xc11_0.xl.m)=-0.277154442 v(xc11_0.xr.m)=0.424804359
Cm11_0 ml11_0 0 1e-16
Rm11_0 ml11_0 ml11_1 3.2
Xd11_1a vs11 sl11_1 vs11 sldrv
Xd11_1b in_act slb11_1 vs11 sldrv
Cs11_1a sl11_1 0 1e-16
Cs11_1b slb11_1 0 1e-16
Xc11_1 sl11_1 slb11_1 ml11_1 0 0 tcam2f dvgl=0 dvgr=0 xl1=-1 xl2=-1 xl3=-1 xl4=-1 xl5=-1 xl6=-1
+ xl7=-1 xl8=-1 xl9=-1 xl10=-1 xl11=-1 xl12=-1 xl13=-1 xl14=-1
+ xl15=-1 xl16=-1 xr1=1 xr2=1 xr3=1 xr4=1 xr5=1 xr6=1
+ xr7=1 xr8=1 xr9=1 xr10=1 xr11=1 xr12=1 xr13=1 xr14=0.999999988
+ xr15=1.00000021 xr16=0.999959662
.ic v(xc11_1.xl.m)=-0.277154442 v(xc11_1.xr.m)=0.424804359
Cm11_1 ml11_1 0 1e-16
Rm11_1 ml11_1 ml11_2 3.2
Xd11_2a vs11 sl11_2 vs11 sldrv
Xd11_2b in_act slb11_2 vs11 sldrv
Cs11_2a sl11_2 0 1e-16
Cs11_2b slb11_2 0 1e-16
Xc11_2 sl11_2 slb11_2 ml11_2 0 0 tcam2f dvgl=0 dvgr=0 xl1=-1 xl2=-1 xl3=-1 xl4=-1 xl5=-1 xl6=-1
+ xl7=-1 xl8=-1 xl9=-1 xl10=-1 xl11=-1 xl12=-1 xl13=-1 xl14=-1
+ xl15=-1 xl16=-1 xr1=1 xr2=1 xr3=1 xr4=1 xr5=1 xr6=1
+ xr7=1 xr8=1 xr9=1 xr10=1 xr11=1 xr12=1 xr13=1 xr14=0.999999988
+ xr15=1.00000021 xr16=0.999959662
.ic v(xc11_2.xl.m)=-0.277154442 v(xc11_2.xr.m)=0.424804359
Cm11_2 ml11_2 0 1e-16
Rm11_2 ml11_2 ml11_3 3.2
Xd11_3a vs11 sl11_3 vs11 sldrv
Xd11_3b in_act slb11_3 vs11 sldrv
Cs11_3a sl11_3 0 1e-16
Cs11_3b slb11_3 0 1e-16
Xc11_3 sl11_3 slb11_3 ml11_3 0 0 tcam2f dvgl=0 dvgr=0 xl1=-1 xl2=-1 xl3=-1 xl4=-1 xl5=-1 xl6=-1
+ xl7=-1 xl8=-1 xl9=-1 xl10=-1 xl11=-1 xl12=-1 xl13=-1 xl14=-1
+ xl15=-1 xl16=-1 xr1=1 xr2=1 xr3=1 xr4=1 xr5=1 xr6=1
+ xr7=1 xr8=1 xr9=1 xr10=1 xr11=1 xr12=1 xr13=1 xr14=0.999999988
+ xr15=1.00000021 xr16=0.999959662
.ic v(xc11_3.xl.m)=-0.277154442 v(xc11_3.xr.m)=0.424804359
Cm11_3 ml11_3 0 1e-16
Rm11_3 ml11_3 ml11_4 3.2
Xd11_4a vs11 sl11_4 vs11 sldrv
Xd11_4b in_act slb11_4 vs11 sldrv
Cs11_4a sl11_4 0 1e-16
Cs11_4b slb11_4 0 1e-16
Xc11_4 sl11_4 slb11_4 ml11_4 0 0 tcam2f dvgl=0 dvgr=0 xl1=1 xl2=1 xl3=1 xl4=1 xl5=1 xl6=1
+ xl7=1 xl8=1 xl9=1 xl10=1 xl11=1 xl12=1 xl13=1 xl14=0.999999988
+ xl15=1.00000021 xl16=0.999959662 xr1=-1 xr2=-1 xr3=-1 xr4=-1 xr5=-1 xr6=-1
+ xr7=-1 xr8=-1 xr9=-1 xr10=-1 xr11=-1 xr12=-1 xr13=-1 xr14=-1
+ xr15=-1 xr16=-1
.ic v(xc11_4.xl.m)=0.424804359 v(xc11_4.xr.m)=-0.277154442
Cm11_4 ml11_4 0 1e-16
Rm11_4 ml11_4 ml11_5 3.2
Xd11_5a vs11 sl11_5 vs11 sldrv
Xd11_5b in_act slb11_5 vs11 sldrv
Cs11_5a sl11_5 0 1e-16
Cs11_5b slb11_5 0 1e-16
Xc11_5 sl11_5 slb11_5 ml11_5 0 0 tcam2f dvgl=0 dvgr=0 xl1=1 xl2=1 xl3=1 xl4=1 xl5=1 xl6=1
+ xl7=1 xl8=1 xl9=1 xl10=1 xl11=1 xl12=1 xl13=1 xl14=0.999999988
+ xl15=1.00000021 xl16=0.999959662 xr1=-1 xr2=-1 xr3=-1 xr4=-1 xr5=-1 xr6=-1
+ xr7=-1 xr8=-1 xr9=-1 xr10=-1 xr11=-1 xr12=-1 xr13=-1 xr14=-1
+ xr15=-1 xr16=-1
.ic v(xc11_5.xl.m)=0.424804359 v(xc11_5.xr.m)=-0.277154442
Cm11_5 ml11_5 0 1e-16
Rm11_5 ml11_5 ml11_6 3.2
Xd11_6a vs11 sl11_6 vs11 sldrv
Xd11_6b in_act slb11_6 vs11 sldrv
Cs11_6a sl11_6 0 1e-16
Cs11_6b slb11_6 0 1e-16
Xc11_6 sl11_6 slb11_6 ml11_6 0 0 tcam2f dvgl=0 dvgr=0 xl1=1 xl2=1 xl3=1 xl4=1 xl5=1 xl6=1
+ xl7=1 xl8=1 xl9=1 xl10=1 xl11=1 xl12=1 xl13=1 xl14=0.999999988
+ xl15=1.00000021 xl16=0.999959662 xr1=-1 xr2=-1 xr3=-1 xr4=-1 xr5=-1 xr6=-1
+ xr7=-1 xr8=-1 xr9=-1 xr10=-1 xr11=-1 xr12=-1 xr13=-1 xr14=-1
+ xr15=-1 xr16=-1
.ic v(xc11_6.xl.m)=0.424804359 v(xc11_6.xr.m)=-0.277154442
Cm11_6 ml11_6 0 1e-16
Rm11_6 ml11_6 ml11_7 3.2
Xd11_7a vs11 sl11_7 vs11 sldrv
Xd11_7b in_act slb11_7 vs11 sldrv
Cs11_7a sl11_7 0 1e-16
Cs11_7b slb11_7 0 1e-16
Xc11_7 sl11_7 slb11_7 ml11_7 0 0 tcam2f dvgl=0 dvgr=0 xl1=1 xl2=1 xl3=1 xl4=1 xl5=1 xl6=1
+ xl7=1 xl8=1 xl9=1 xl10=1 xl11=1 xl12=1 xl13=1 xl14=0.999999988
+ xl15=1.00000021 xl16=0.999959662 xr1=-1 xr2=-1 xr3=-1 xr4=-1 xr5=-1 xr6=-1
+ xr7=-1 xr8=-1 xr9=-1 xr10=-1 xr11=-1 xr12=-1 xr13=-1 xr14=-1
+ xr15=-1 xr16=-1
.ic v(xc11_7.xl.m)=0.424804359 v(xc11_7.xr.m)=-0.277154442
Cm11_7 ml11_7 0 1e-16
Xp11 ml11_0 preb vdd11 mlpre
Xsa11 ml11_0 miss11 match11 vdd11 mlsa
.ic v(ml11_0)=1.0 v(ml11_1)=1.0 v(ml11_2)=1.0 v(ml11_3)=1.0 v(ml11_4)=1.0 v(ml11_5)=1.0 v(ml11_6)=1.0 v(ml11_7)=1.0 v(match11)=1.0
* word 12: stored 1X0X1X0X key 10011001 -> 0 mismatch(es)
Vdd12 vdd12 0 1.0
Vs12 vs12 0 1.1
Xd12_0a in_act sl12_0 vs12 sldrv
Xd12_0b vs12 slb12_0 vs12 sldrv
Cs12_0a sl12_0 0 1e-16
Cs12_0b slb12_0 0 1e-16
Xc12_0 sl12_0 slb12_0 ml12_0 0 0 tcam2f dvgl=0 dvgr=0 xl1=-1 xl2=-1 xl3=-1 xl4=-1 xl5=-1 xl6=-1
+ xl7=-1 xl8=-1 xl9=-1 xl10=-1 xl11=-1 xl12=-1 xl13=-1 xl14=-1
+ xl15=-1 xl16=-1 xr1=1 xr2=1 xr3=1 xr4=1 xr5=1 xr6=1
+ xr7=1 xr8=1 xr9=1 xr10=1 xr11=1 xr12=1 xr13=1 xr14=0.999999988
+ xr15=1.00000021 xr16=0.999959662
.ic v(xc12_0.xl.m)=-0.277154442 v(xc12_0.xr.m)=0.424804359
Cm12_0 ml12_0 0 1e-16
Rm12_0 ml12_0 ml12_1 3.2
Xd12_1a vs12 sl12_1 vs12 sldrv
Xd12_1b in_act slb12_1 vs12 sldrv
Cs12_1a sl12_1 0 1e-16
Cs12_1b slb12_1 0 1e-16
Xc12_1 sl12_1 slb12_1 ml12_1 0 0 tcam2f dvgl=0 dvgr=0 xl1=-1 xl2=-1 xl3=-1 xl4=-1 xl5=-1 xl6=-1
+ xl7=-1 xl8=-1 xl9=-1 xl10=-1 xl11=-1 xl12=-1 xl13=-1 xl14=-1
+ xl15=-1 xl16=-1 xr1=-1 xr2=-1 xr3=-1 xr4=-1 xr5=-1 xr6=-1
+ xr7=-1 xr8=-1 xr9=-1 xr10=-1 xr11=-1 xr12=-1 xr13=-1 xr14=-1
+ xr15=-1 xr16=-1
.ic v(xc12_1.xl.m)=-0.277154442 v(xc12_1.xr.m)=-0.277154442
Cm12_1 ml12_1 0 1e-16
Rm12_1 ml12_1 ml12_2 3.2
Xd12_2a vs12 sl12_2 vs12 sldrv
Xd12_2b in_act slb12_2 vs12 sldrv
Cs12_2a sl12_2 0 1e-16
Cs12_2b slb12_2 0 1e-16
Xc12_2 sl12_2 slb12_2 ml12_2 0 0 tcam2f dvgl=0 dvgr=0 xl1=1 xl2=1 xl3=1 xl4=1 xl5=1 xl6=1
+ xl7=1 xl8=1 xl9=1 xl10=1 xl11=1 xl12=1 xl13=1 xl14=0.999999988
+ xl15=1.00000021 xl16=0.999959662 xr1=-1 xr2=-1 xr3=-1 xr4=-1 xr5=-1 xr6=-1
+ xr7=-1 xr8=-1 xr9=-1 xr10=-1 xr11=-1 xr12=-1 xr13=-1 xr14=-1
+ xr15=-1 xr16=-1
.ic v(xc12_2.xl.m)=0.424804359 v(xc12_2.xr.m)=-0.277154442
Cm12_2 ml12_2 0 1e-16
Rm12_2 ml12_2 ml12_3 3.2
Xd12_3a in_act sl12_3 vs12 sldrv
Xd12_3b vs12 slb12_3 vs12 sldrv
Cs12_3a sl12_3 0 1e-16
Cs12_3b slb12_3 0 1e-16
Xc12_3 sl12_3 slb12_3 ml12_3 0 0 tcam2f dvgl=0 dvgr=0 xl1=-1 xl2=-1 xl3=-1 xl4=-1 xl5=-1 xl6=-1
+ xl7=-1 xl8=-1 xl9=-1 xl10=-1 xl11=-1 xl12=-1 xl13=-1 xl14=-1
+ xl15=-1 xl16=-1 xr1=-1 xr2=-1 xr3=-1 xr4=-1 xr5=-1 xr6=-1
+ xr7=-1 xr8=-1 xr9=-1 xr10=-1 xr11=-1 xr12=-1 xr13=-1 xr14=-1
+ xr15=-1 xr16=-1
.ic v(xc12_3.xl.m)=-0.277154442 v(xc12_3.xr.m)=-0.277154442
Cm12_3 ml12_3 0 1e-16
Rm12_3 ml12_3 ml12_4 3.2
Xd12_4a in_act sl12_4 vs12 sldrv
Xd12_4b vs12 slb12_4 vs12 sldrv
Cs12_4a sl12_4 0 1e-16
Cs12_4b slb12_4 0 1e-16
Xc12_4 sl12_4 slb12_4 ml12_4 0 0 tcam2f dvgl=0 dvgr=0 xl1=-1 xl2=-1 xl3=-1 xl4=-1 xl5=-1 xl6=-1
+ xl7=-1 xl8=-1 xl9=-1 xl10=-1 xl11=-1 xl12=-1 xl13=-1 xl14=-1
+ xl15=-1 xl16=-1 xr1=1 xr2=1 xr3=1 xr4=1 xr5=1 xr6=1
+ xr7=1 xr8=1 xr9=1 xr10=1 xr11=1 xr12=1 xr13=1 xr14=0.999999988
+ xr15=1.00000021 xr16=0.999959662
.ic v(xc12_4.xl.m)=-0.277154442 v(xc12_4.xr.m)=0.424804359
Cm12_4 ml12_4 0 1e-16
Rm12_4 ml12_4 ml12_5 3.2
Xd12_5a vs12 sl12_5 vs12 sldrv
Xd12_5b in_act slb12_5 vs12 sldrv
Cs12_5a sl12_5 0 1e-16
Cs12_5b slb12_5 0 1e-16
Xc12_5 sl12_5 slb12_5 ml12_5 0 0 tcam2f dvgl=0 dvgr=0 xl1=-1 xl2=-1 xl3=-1 xl4=-1 xl5=-1 xl6=-1
+ xl7=-1 xl8=-1 xl9=-1 xl10=-1 xl11=-1 xl12=-1 xl13=-1 xl14=-1
+ xl15=-1 xl16=-1 xr1=-1 xr2=-1 xr3=-1 xr4=-1 xr5=-1 xr6=-1
+ xr7=-1 xr8=-1 xr9=-1 xr10=-1 xr11=-1 xr12=-1 xr13=-1 xr14=-1
+ xr15=-1 xr16=-1
.ic v(xc12_5.xl.m)=-0.277154442 v(xc12_5.xr.m)=-0.277154442
Cm12_5 ml12_5 0 1e-16
Rm12_5 ml12_5 ml12_6 3.2
Xd12_6a vs12 sl12_6 vs12 sldrv
Xd12_6b in_act slb12_6 vs12 sldrv
Cs12_6a sl12_6 0 1e-16
Cs12_6b slb12_6 0 1e-16
Xc12_6 sl12_6 slb12_6 ml12_6 0 0 tcam2f dvgl=0 dvgr=0 xl1=1 xl2=1 xl3=1 xl4=1 xl5=1 xl6=1
+ xl7=1 xl8=1 xl9=1 xl10=1 xl11=1 xl12=1 xl13=1 xl14=0.999999988
+ xl15=1.00000021 xl16=0.999959662 xr1=-1 xr2=-1 xr3=-1 xr4=-1 xr5=-1 xr6=-1
+ xr7=-1 xr8=-1 xr9=-1 xr10=-1 xr11=-1 xr12=-1 xr13=-1 xr14=-1
+ xr15=-1 xr16=-1
.ic v(xc12_6.xl.m)=0.424804359 v(xc12_6.xr.m)=-0.277154442
Cm12_6 ml12_6 0 1e-16
Rm12_6 ml12_6 ml12_7 3.2
Xd12_7a in_act sl12_7 vs12 sldrv
Xd12_7b vs12 slb12_7 vs12 sldrv
Cs12_7a sl12_7 0 1e-16
Cs12_7b slb12_7 0 1e-16
Xc12_7 sl12_7 slb12_7 ml12_7 0 0 tcam2f dvgl=0 dvgr=0 xl1=-1 xl2=-1 xl3=-1 xl4=-1 xl5=-1 xl6=-1
+ xl7=-1 xl8=-1 xl9=-1 xl10=-1 xl11=-1 xl12=-1 xl13=-1 xl14=-1
+ xl15=-1 xl16=-1 xr1=-1 xr2=-1 xr3=-1 xr4=-1 xr5=-1 xr6=-1
+ xr7=-1 xr8=-1 xr9=-1 xr10=-1 xr11=-1 xr12=-1 xr13=-1 xr14=-1
+ xr15=-1 xr16=-1
.ic v(xc12_7.xl.m)=-0.277154442 v(xc12_7.xr.m)=-0.277154442
Cm12_7 ml12_7 0 1e-16
Xp12 ml12_0 preb vdd12 mlpre
Xsa12 ml12_0 miss12 match12 vdd12 mlsa
.ic v(ml12_0)=1.0 v(ml12_1)=1.0 v(ml12_2)=1.0 v(ml12_3)=1.0 v(ml12_4)=1.0 v(ml12_5)=1.0 v(ml12_6)=1.0 v(ml12_7)=1.0 v(match12)=1.0
* word 13: stored 1X0X1X0X key 01111100 -> 2 mismatch(es)
Vdd13 vdd13 0 1.0
Vs13 vs13 0 1.1
Xd13_0a vs13 sl13_0 vs13 sldrv
Xd13_0b in_act slb13_0 vs13 sldrv
Cs13_0a sl13_0 0 1e-16
Cs13_0b slb13_0 0 1e-16
Xc13_0 sl13_0 slb13_0 ml13_0 0 0 tcam2f dvgl=0 dvgr=0 xl1=-1 xl2=-1 xl3=-1 xl4=-1 xl5=-1 xl6=-1
+ xl7=-1 xl8=-1 xl9=-1 xl10=-1 xl11=-1 xl12=-1 xl13=-1 xl14=-1
+ xl15=-1 xl16=-1 xr1=1 xr2=1 xr3=1 xr4=1 xr5=1 xr6=1
+ xr7=1 xr8=1 xr9=1 xr10=1 xr11=1 xr12=1 xr13=1 xr14=0.999999988
+ xr15=1.00000021 xr16=0.999959662
.ic v(xc13_0.xl.m)=-0.277154442 v(xc13_0.xr.m)=0.424804359
Cm13_0 ml13_0 0 1e-16
Rm13_0 ml13_0 ml13_1 3.2
Xd13_1a in_act sl13_1 vs13 sldrv
Xd13_1b vs13 slb13_1 vs13 sldrv
Cs13_1a sl13_1 0 1e-16
Cs13_1b slb13_1 0 1e-16
Xc13_1 sl13_1 slb13_1 ml13_1 0 0 tcam2f dvgl=0 dvgr=0 xl1=-1 xl2=-1 xl3=-1 xl4=-1 xl5=-1 xl6=-1
+ xl7=-1 xl8=-1 xl9=-1 xl10=-1 xl11=-1 xl12=-1 xl13=-1 xl14=-1
+ xl15=-1 xl16=-1 xr1=-1 xr2=-1 xr3=-1 xr4=-1 xr5=-1 xr6=-1
+ xr7=-1 xr8=-1 xr9=-1 xr10=-1 xr11=-1 xr12=-1 xr13=-1 xr14=-1
+ xr15=-1 xr16=-1
.ic v(xc13_1.xl.m)=-0.277154442 v(xc13_1.xr.m)=-0.277154442
Cm13_1 ml13_1 0 1e-16
Rm13_1 ml13_1 ml13_2 3.2
Xd13_2a in_act sl13_2 vs13 sldrv
Xd13_2b vs13 slb13_2 vs13 sldrv
Cs13_2a sl13_2 0 1e-16
Cs13_2b slb13_2 0 1e-16
Xc13_2 sl13_2 slb13_2 ml13_2 0 0 tcam2f dvgl=0 dvgr=0 xl1=1 xl2=1 xl3=1 xl4=1 xl5=1 xl6=1
+ xl7=1 xl8=1 xl9=1 xl10=1 xl11=1 xl12=1 xl13=1 xl14=0.999999988
+ xl15=1.00000021 xl16=0.999959662 xr1=-1 xr2=-1 xr3=-1 xr4=-1 xr5=-1 xr6=-1
+ xr7=-1 xr8=-1 xr9=-1 xr10=-1 xr11=-1 xr12=-1 xr13=-1 xr14=-1
+ xr15=-1 xr16=-1
.ic v(xc13_2.xl.m)=0.424804359 v(xc13_2.xr.m)=-0.277154442
Cm13_2 ml13_2 0 1e-16
Rm13_2 ml13_2 ml13_3 3.2
Xd13_3a in_act sl13_3 vs13 sldrv
Xd13_3b vs13 slb13_3 vs13 sldrv
Cs13_3a sl13_3 0 1e-16
Cs13_3b slb13_3 0 1e-16
Xc13_3 sl13_3 slb13_3 ml13_3 0 0 tcam2f dvgl=0 dvgr=0 xl1=-1 xl2=-1 xl3=-1 xl4=-1 xl5=-1 xl6=-1
+ xl7=-1 xl8=-1 xl9=-1 xl10=-1 xl11=-1 xl12=-1 xl13=-1 xl14=-1
+ xl15=-1 xl16=-1 xr1=-1 xr2=-1 xr3=-1 xr4=-1 xr5=-1 xr6=-1
+ xr7=-1 xr8=-1 xr9=-1 xr10=-1 xr11=-1 xr12=-1 xr13=-1 xr14=-1
+ xr15=-1 xr16=-1
.ic v(xc13_3.xl.m)=-0.277154442 v(xc13_3.xr.m)=-0.277154442
Cm13_3 ml13_3 0 1e-16
Rm13_3 ml13_3 ml13_4 3.2
Xd13_4a in_act sl13_4 vs13 sldrv
Xd13_4b vs13 slb13_4 vs13 sldrv
Cs13_4a sl13_4 0 1e-16
Cs13_4b slb13_4 0 1e-16
Xc13_4 sl13_4 slb13_4 ml13_4 0 0 tcam2f dvgl=0 dvgr=0 xl1=-1 xl2=-1 xl3=-1 xl4=-1 xl5=-1 xl6=-1
+ xl7=-1 xl8=-1 xl9=-1 xl10=-1 xl11=-1 xl12=-1 xl13=-1 xl14=-1
+ xl15=-1 xl16=-1 xr1=1 xr2=1 xr3=1 xr4=1 xr5=1 xr6=1
+ xr7=1 xr8=1 xr9=1 xr10=1 xr11=1 xr12=1 xr13=1 xr14=0.999999988
+ xr15=1.00000021 xr16=0.999959662
.ic v(xc13_4.xl.m)=-0.277154442 v(xc13_4.xr.m)=0.424804359
Cm13_4 ml13_4 0 1e-16
Rm13_4 ml13_4 ml13_5 3.2
Xd13_5a in_act sl13_5 vs13 sldrv
Xd13_5b vs13 slb13_5 vs13 sldrv
Cs13_5a sl13_5 0 1e-16
Cs13_5b slb13_5 0 1e-16
Xc13_5 sl13_5 slb13_5 ml13_5 0 0 tcam2f dvgl=0 dvgr=0 xl1=-1 xl2=-1 xl3=-1 xl4=-1 xl5=-1 xl6=-1
+ xl7=-1 xl8=-1 xl9=-1 xl10=-1 xl11=-1 xl12=-1 xl13=-1 xl14=-1
+ xl15=-1 xl16=-1 xr1=-1 xr2=-1 xr3=-1 xr4=-1 xr5=-1 xr6=-1
+ xr7=-1 xr8=-1 xr9=-1 xr10=-1 xr11=-1 xr12=-1 xr13=-1 xr14=-1
+ xr15=-1 xr16=-1
.ic v(xc13_5.xl.m)=-0.277154442 v(xc13_5.xr.m)=-0.277154442
Cm13_5 ml13_5 0 1e-16
Rm13_5 ml13_5 ml13_6 3.2
Xd13_6a vs13 sl13_6 vs13 sldrv
Xd13_6b in_act slb13_6 vs13 sldrv
Cs13_6a sl13_6 0 1e-16
Cs13_6b slb13_6 0 1e-16
Xc13_6 sl13_6 slb13_6 ml13_6 0 0 tcam2f dvgl=0 dvgr=0 xl1=1 xl2=1 xl3=1 xl4=1 xl5=1 xl6=1
+ xl7=1 xl8=1 xl9=1 xl10=1 xl11=1 xl12=1 xl13=1 xl14=0.999999988
+ xl15=1.00000021 xl16=0.999959662 xr1=-1 xr2=-1 xr3=-1 xr4=-1 xr5=-1 xr6=-1
+ xr7=-1 xr8=-1 xr9=-1 xr10=-1 xr11=-1 xr12=-1 xr13=-1 xr14=-1
+ xr15=-1 xr16=-1
.ic v(xc13_6.xl.m)=0.424804359 v(xc13_6.xr.m)=-0.277154442
Cm13_6 ml13_6 0 1e-16
Rm13_6 ml13_6 ml13_7 3.2
Xd13_7a vs13 sl13_7 vs13 sldrv
Xd13_7b in_act slb13_7 vs13 sldrv
Cs13_7a sl13_7 0 1e-16
Cs13_7b slb13_7 0 1e-16
Xc13_7 sl13_7 slb13_7 ml13_7 0 0 tcam2f dvgl=0 dvgr=0 xl1=-1 xl2=-1 xl3=-1 xl4=-1 xl5=-1 xl6=-1
+ xl7=-1 xl8=-1 xl9=-1 xl10=-1 xl11=-1 xl12=-1 xl13=-1 xl14=-1
+ xl15=-1 xl16=-1 xr1=-1 xr2=-1 xr3=-1 xr4=-1 xr5=-1 xr6=-1
+ xr7=-1 xr8=-1 xr9=-1 xr10=-1 xr11=-1 xr12=-1 xr13=-1 xr14=-1
+ xr15=-1 xr16=-1
.ic v(xc13_7.xl.m)=-0.277154442 v(xc13_7.xr.m)=-0.277154442
Cm13_7 ml13_7 0 1e-16
Xp13 ml13_0 preb vdd13 mlpre
Xsa13 ml13_0 miss13 match13 vdd13 mlsa
.ic v(ml13_0)=1.0 v(ml13_1)=1.0 v(ml13_2)=1.0 v(ml13_3)=1.0 v(ml13_4)=1.0 v(ml13_5)=1.0 v(ml13_6)=1.0 v(ml13_7)=1.0 v(match13)=1.0
.control
set wr_singlescale
set wr_vecnames
tran 1n 8.2e-09 0 5e-12 uic
wrdata sim/out/t3b/t3b_word8.csv v(ml0_0) v(miss0) i(vdd0) i(vs0) v(ml1_0) v(miss1) i(vdd1) i(vs1)
+ v(ml2_0) v(miss2) i(vdd2) i(vs2) v(ml3_0) v(miss3) i(vdd3) i(vs3)
+ v(ml4_0) v(miss4) i(vdd4) i(vs4) v(ml5_0) v(miss5) i(vdd5) i(vs5)
+ v(ml6_0) v(miss6) i(vdd6) i(vs6) v(ml7_0) v(miss7) i(vdd7) i(vs7)
+ v(ml8_0) v(miss8) i(vdd8) i(vs8) v(ml9_0) v(miss9) i(vdd9) i(vs9)
+ v(ml10_0) v(miss10) i(vdd10) i(vs10) v(ml11_0) v(miss11) i(vdd11) i(vs11)
+ v(ml12_0) v(miss12) i(vdd12) i(vs12) v(ml13_0) v(miss13) i(vdd13) i(vs13)
.endc
.end
